* NGSPICE file created from chip_top.ext - technology: sky130A

.subckt sky130_fd_sc_hd__decap_6 VNB VPB VPWR VGND
X0 VPWR VGND VPWR VPB sky130_fd_pr__pfet_01v8_hvt ad=0.2262 pd=2.26 as=0.4524 ps=4.52 w=0.87 l=1.97
X1 VGND VPWR VGND VNB sky130_fd_pr__nfet_01v8 ad=0.143 pd=1.62 as=0.286 ps=3.24 w=0.55 l=1.97
.ends

.subckt sky130_fd_sc_hd__o21ai_0 VNB VPB VGND VPWR B1 A1 Y A2 a_32_47#
X0 a_120_369# A1 VPWR VPB sky130_fd_pr__pfet_01v8_hvt ad=0.0768 pd=0.88 as=0.1696 ps=1.81 w=0.64 l=0.15
X1 VGND A1 a_32_47# VNB sky130_fd_pr__nfet_01v8 ad=0.0588 pd=0.7 as=0.1113 ps=1.37 w=0.42 l=0.15
X2 Y A2 a_120_369# VPB sky130_fd_pr__pfet_01v8_hvt ad=0.0896 pd=0.92 as=0.0768 ps=0.88 w=0.64 l=0.15
X3 a_32_47# A2 VGND VNB sky130_fd_pr__nfet_01v8 ad=0.0588 pd=0.7 as=0.0588 ps=0.7 w=0.42 l=0.15
X4 VPWR B1 Y VPB sky130_fd_pr__pfet_01v8_hvt ad=0.1824 pd=1.85 as=0.0896 ps=0.92 w=0.64 l=0.15
X5 Y B1 a_32_47# VNB sky130_fd_pr__nfet_01v8 ad=0.1113 pd=1.37 as=0.0588 ps=0.7 w=0.42 l=0.15
.ends

.subckt sky130_fd_sc_hd__clkinv_1 VNB VPB VGND VPWR A Y
X0 Y A VPWR VPB sky130_fd_pr__pfet_01v8_hvt ad=0.1134 pd=1.11 as=0.2184 ps=2.2 w=0.84 l=0.15
X1 VGND A Y VNB sky130_fd_pr__nfet_01v8 ad=0.1197 pd=1.41 as=0.1092 ps=1.36 w=0.42 l=0.15
X2 VPWR A Y VPB sky130_fd_pr__pfet_01v8_hvt ad=0.2352 pd=2.24 as=0.1134 ps=1.11 w=0.84 l=0.15
.ends

.subckt sky130_fd_sc_hd__decap_12 VNB VPB VGND VPWR
X0 VPWR VGND VPWR VPB sky130_fd_pr__pfet_01v8_hvt ad=0.2262 pd=2.26 as=0.4524 ps=4.52 w=0.87 l=4.73
X1 VGND VPWR VGND VNB sky130_fd_pr__nfet_01v8 ad=0.143 pd=1.62 as=0.286 ps=3.24 w=0.55 l=4.73
.ends

.subckt sky130_fd_sc_hd__dfxtp_1 VNB VPB VPWR VGND CLK D Q a_975_413# a_891_413# a_466_413#
+ a_592_47# a_1059_315# a_193_47# a_561_413# a_634_159# a_381_47# a_27_47#
X0 Q a_1059_315# VGND VNB sky130_fd_pr__nfet_01v8 ad=0.169 pd=1.82 as=0.08775 ps=0.92 w=0.65 l=0.15
X1 a_891_413# a_193_47# a_634_159# VNB sky130_fd_pr__special_nfet_01v8 ad=0.0684 pd=0.74 as=0.0989 ps=0.995 w=0.36 l=0.15
X2 a_561_413# a_27_47# a_466_413# VPB sky130_fd_pr__pfet_01v8_hvt ad=0.07665 pd=0.785 as=0.06825 ps=0.745 w=0.42 l=0.15
X3 VPWR CLK a_27_47# VPB sky130_fd_pr__pfet_01v8_hvt ad=0.0864 pd=0.91 as=0.1664 ps=1.8 w=0.64 l=0.15
X4 Q a_1059_315# VPWR VPB sky130_fd_pr__pfet_01v8_hvt ad=0.26 pd=2.52 as=0.135 ps=1.27 w=1 l=0.15
X5 a_381_47# D VPWR VPB sky130_fd_pr__pfet_01v8_hvt ad=0.05775 pd=0.695 as=0.1092 ps=1.36 w=0.42 l=0.15
X6 VGND a_634_159# a_592_47# VNB sky130_fd_pr__nfet_01v8 ad=0.12095 pd=1.085 as=0.0696 ps=0.765 w=0.42 l=0.15
X7 VPWR a_891_413# a_1059_315# VPB sky130_fd_pr__pfet_01v8_hvt ad=0.135 pd=1.27 as=0.27 ps=2.54 w=1 l=0.15
X8 a_466_413# a_193_47# a_381_47# VPB sky130_fd_pr__pfet_01v8_hvt ad=0.06825 pd=0.745 as=0.05775 ps=0.695 w=0.42 l=0.15
X9 VPWR a_634_159# a_561_413# VPB sky130_fd_pr__pfet_01v8_hvt ad=0.17887 pd=1.26 as=0.07665 ps=0.785 w=0.42 l=0.15
X10 a_634_159# a_466_413# VGND VNB sky130_fd_pr__nfet_01v8 ad=0.0989 pd=0.995 as=0.12095 ps=1.085 w=0.64 l=0.15
X11 a_634_159# a_466_413# VPWR VPB sky130_fd_pr__pfet_01v8_hvt ad=0.1095 pd=1.075 as=0.17887 ps=1.26 w=0.75 l=0.15
X12 a_975_413# a_193_47# a_891_413# VPB sky130_fd_pr__pfet_01v8_hvt ad=0.0882 pd=0.84 as=0.0567 ps=0.69 w=0.42 l=0.15
X13 VGND a_1059_315# a_1017_47# VNB sky130_fd_pr__nfet_01v8 ad=0.1092 pd=1.36 as=0.066 ps=0.745 w=0.42 l=0.15
X14 a_193_47# a_27_47# VGND VNB sky130_fd_pr__nfet_01v8 ad=0.1092 pd=1.36 as=0.0567 ps=0.69 w=0.42 l=0.15
X15 a_891_413# a_27_47# a_634_159# VPB sky130_fd_pr__pfet_01v8_hvt ad=0.0567 pd=0.69 as=0.1095 ps=1.075 w=0.42 l=0.15
X16 a_592_47# a_193_47# a_466_413# VNB sky130_fd_pr__special_nfet_01v8 ad=0.0696 pd=0.765 as=0.0621 ps=0.705 w=0.36 l=0.15
X17 VPWR a_1059_315# a_975_413# VPB sky130_fd_pr__pfet_01v8_hvt ad=0.1113 pd=1.37 as=0.0882 ps=0.84 w=0.42 l=0.15
X18 a_1017_47# a_27_47# a_891_413# VNB sky130_fd_pr__special_nfet_01v8 ad=0.066 pd=0.745 as=0.0684 ps=0.74 w=0.36 l=0.15
X19 a_193_47# a_27_47# VPWR VPB sky130_fd_pr__pfet_01v8_hvt ad=0.1664 pd=1.8 as=0.0864 ps=0.91 w=0.64 l=0.15
X20 a_466_413# a_27_47# a_381_47# VNB sky130_fd_pr__special_nfet_01v8 ad=0.0621 pd=0.705 as=0.0813 ps=0.83 w=0.36 l=0.15
X21 VGND a_891_413# a_1059_315# VNB sky130_fd_pr__nfet_01v8 ad=0.08775 pd=0.92 as=0.169 ps=1.82 w=0.65 l=0.15
X22 a_381_47# D VGND VNB sky130_fd_pr__nfet_01v8 ad=0.0813 pd=0.83 as=0.1092 ps=1.36 w=0.42 l=0.15
X23 VGND CLK a_27_47# VNB sky130_fd_pr__nfet_01v8 ad=0.0567 pd=0.69 as=0.1092 ps=1.36 w=0.42 l=0.15
.ends

.subckt sky130_fd_sc_hd__mux2i_1 VNB VPB VGND VPWR A0 Y A1 S a_27_297# a_193_47# a_283_205#
+ a_27_47#
X0 a_27_297# S VPWR VPB sky130_fd_pr__pfet_01v8_hvt ad=0.26 pd=2.52 as=0.3 ps=1.6 w=1 l=0.15
X1 VGND S a_283_205# VNB sky130_fd_pr__nfet_01v8 ad=0.169 pd=1.82 as=0.169 ps=1.82 w=0.65 l=0.15
X2 a_204_297# A1 Y VPB sky130_fd_pr__pfet_01v8_hvt ad=0.1975 pd=1.395 as=0.1525 ps=1.305 w=1 l=0.15
X3 a_193_47# A1 Y VNB sky130_fd_pr__nfet_01v8 ad=0.182 pd=1.86 as=0.08775 ps=0.92 w=0.65 l=0.15
X4 Y A0 a_27_297# VPB sky130_fd_pr__pfet_01v8_hvt ad=0.1525 pd=1.305 as=0.28 ps=2.56 w=1 l=0.15
X5 VPWR a_283_205# a_204_297# VPB sky130_fd_pr__pfet_01v8_hvt ad=0.3 pd=1.6 as=0.1975 ps=1.395 w=1 l=0.15
X6 VPWR S a_283_205# VPB sky130_fd_pr__pfet_01v8_hvt ad=0.26 pd=2.52 as=0.29 ps=2.58 w=1 l=0.15
X7 VGND a_283_205# a_27_47# VNB sky130_fd_pr__nfet_01v8 ad=0.08775 pd=0.92 as=0.169 ps=1.82 w=0.65 l=0.15
X8 a_193_47# S VGND VNB sky130_fd_pr__nfet_01v8 ad=0.169 pd=1.82 as=0.08775 ps=0.92 w=0.65 l=0.15
X9 Y A0 a_27_47# VNB sky130_fd_pr__nfet_01v8 ad=0.08775 pd=0.92 as=0.169 ps=1.82 w=0.65 l=0.15
.ends

.subckt sky130_fd_sc_hd__decap_3 VNB VPB VPWR VGND
X0 VPWR VGND VPWR VPB sky130_fd_pr__pfet_01v8_hvt ad=0.2262 pd=2.26 as=0.4524 ps=4.52 w=0.87 l=0.59
X1 VGND VPWR VGND VNB sky130_fd_pr__nfet_01v8 ad=0.143 pd=1.62 as=0.286 ps=3.24 w=0.55 l=0.59
.ends

.subckt sky130_fd_sc_hd__edfxtp_1 VNB VPB VPWR VGND CLK DE Q D a_1717_47# a_1514_47#
+ a_423_343# a_1500_413# a_729_47# a_299_47# a_986_413# a_1150_159# a_193_47# a_729_369#
+ a_791_264# a_1675_413# a_1591_413# a_27_47#
X0 a_381_369# D a_299_47# VPB sky130_fd_pr__pfet_01v8_hvt ad=0.0672 pd=0.85 as=0.1664 ps=1.8 w=0.64 l=0.15
X1 VGND a_1591_413# a_791_264# VNB sky130_fd_pr__nfet_01v8 ad=0.10025 pd=0.985 as=0.1092 ps=1.36 w=0.42 l=0.15
X2 VPWR DE a_423_343# VPB sky130_fd_pr__pfet_01v8_hvt ad=0.0928 pd=0.93 as=0.1664 ps=1.8 w=0.64 l=0.15
X3 VPWR CLK a_27_47# VPB sky130_fd_pr__pfet_01v8_hvt ad=0.0864 pd=0.91 as=0.1664 ps=1.8 w=0.64 l=0.15
X4 a_1591_413# a_193_47# a_1514_47# VNB sky130_fd_pr__special_nfet_01v8 ad=0.0684 pd=0.74 as=0.0678 ps=0.755 w=0.36 l=0.15
X5 a_986_413# a_193_47# a_299_47# VPB sky130_fd_pr__pfet_01v8_hvt ad=0.06405 pd=0.725 as=0.15985 ps=1.265 w=0.42 l=0.15
X6 Q a_1591_413# VPWR VPB sky130_fd_pr__pfet_01v8_hvt ad=0.28 pd=2.56 as=0.154 ps=1.335 w=1 l=0.15
X7 VGND DE a_423_343# VNB sky130_fd_pr__nfet_01v8 ad=0.0609 pd=0.71 as=0.1092 ps=1.36 w=0.42 l=0.15
X8 a_1500_413# a_1150_159# VPWR VPB sky130_fd_pr__pfet_01v8_hvt ad=0.06405 pd=0.725 as=0.1092 ps=1.36 w=0.42 l=0.15
X9 a_1101_47# a_193_47# a_986_413# VNB sky130_fd_pr__special_nfet_01v8 ad=0.0759 pd=0.8 as=0.0522 ps=0.65 w=0.36 l=0.15
X10 a_1514_47# a_1150_159# VGND VNB sky130_fd_pr__nfet_01v8 ad=0.0678 pd=0.755 as=0.1092 ps=1.36 w=0.42 l=0.15
X11 a_1675_413# a_193_47# a_1591_413# VPB sky130_fd_pr__pfet_01v8_hvt ad=0.0882 pd=0.84 as=0.0567 ps=0.69 w=0.42 l=0.15
X12 a_193_47# a_27_47# VGND VNB sky130_fd_pr__nfet_01v8 ad=0.1092 pd=1.36 as=0.0567 ps=0.69 w=0.42 l=0.15
X13 a_1591_413# a_27_47# a_1500_413# VPB sky130_fd_pr__pfet_01v8_hvt ad=0.0567 pd=0.69 as=0.06405 ps=0.725 w=0.42 l=0.15
X14 a_729_47# a_423_343# VGND VNB sky130_fd_pr__nfet_01v8 ad=0.0756 pd=0.78 as=0.0609 ps=0.71 w=0.42 l=0.15
X15 a_729_369# DE VPWR VPB sky130_fd_pr__pfet_01v8_hvt ad=0.1152 pd=1 as=0.0928 ps=0.93 w=0.64 l=0.15
X16 a_1077_413# a_27_47# a_986_413# VPB sky130_fd_pr__pfet_01v8_hvt ad=0.07665 pd=0.785 as=0.06405 ps=0.725 w=0.42 l=0.15
X17 VPWR a_791_264# a_1675_413# VPB sky130_fd_pr__pfet_01v8_hvt ad=0.1113 pd=1.37 as=0.0882 ps=0.84 w=0.42 l=0.15
X18 Q a_1591_413# VGND VNB sky130_fd_pr__nfet_01v8 ad=0.182 pd=1.86 as=0.10025 ps=0.985 w=0.65 l=0.15
X19 a_299_47# a_791_264# a_729_47# VNB sky130_fd_pr__nfet_01v8 ad=0.1446 pd=1.18 as=0.0756 ps=0.78 w=0.42 l=0.15
X20 VPWR a_1591_413# a_791_264# VPB sky130_fd_pr__pfet_01v8_hvt ad=0.154 pd=1.335 as=0.1728 ps=1.82 w=0.64 l=0.15
X21 VGND a_791_264# a_1717_47# VNB sky130_fd_pr__nfet_01v8 ad=0.1092 pd=1.36 as=0.066 ps=0.745 w=0.42 l=0.15
X22 a_193_47# a_27_47# VPWR VPB sky130_fd_pr__pfet_01v8_hvt ad=0.1664 pd=1.8 as=0.0864 ps=0.91 w=0.64 l=0.15
X23 VPWR a_1150_159# a_1077_413# VPB sky130_fd_pr__pfet_01v8_hvt ad=0.17887 pd=1.26 as=0.07665 ps=0.785 w=0.42 l=0.15
X24 a_1717_47# a_27_47# a_1591_413# VNB sky130_fd_pr__special_nfet_01v8 ad=0.066 pd=0.745 as=0.0684 ps=0.74 w=0.36 l=0.15
X25 a_1150_159# a_986_413# VPWR VPB sky130_fd_pr__pfet_01v8_hvt ad=0.195 pd=2.02 as=0.17887 ps=1.26 w=0.75 l=0.15
X26 a_986_413# a_27_47# a_299_47# VNB sky130_fd_pr__special_nfet_01v8 ad=0.0522 pd=0.65 as=0.1446 ps=1.18 w=0.36 l=0.15
X27 a_299_47# a_791_264# a_729_369# VPB sky130_fd_pr__pfet_01v8_hvt ad=0.15985 pd=1.265 as=0.1152 ps=1 w=0.64 l=0.15
X28 a_381_47# D a_299_47# VNB sky130_fd_pr__nfet_01v8 ad=0.0441 pd=0.63 as=0.1092 ps=1.36 w=0.42 l=0.15
X29 VGND a_1150_159# a_1101_47# VNB sky130_fd_pr__nfet_01v8 ad=0.12095 pd=1.085 as=0.0759 ps=0.8 w=0.42 l=0.15
X30 VPWR a_423_343# a_381_369# VPB sky130_fd_pr__pfet_01v8_hvt ad=0.1664 pd=1.8 as=0.0672 ps=0.85 w=0.64 l=0.15
X31 VGND CLK a_27_47# VNB sky130_fd_pr__nfet_01v8 ad=0.0567 pd=0.69 as=0.1092 ps=1.36 w=0.42 l=0.15
X32 VGND DE a_381_47# VNB sky130_fd_pr__nfet_01v8 ad=0.1092 pd=1.36 as=0.0441 ps=0.63 w=0.42 l=0.15
X33 a_1150_159# a_986_413# VGND VNB sky130_fd_pr__nfet_01v8 ad=0.1664 pd=1.8 as=0.12095 ps=1.085 w=0.64 l=0.15
.ends

.subckt sky130_fd_sc_hd__nand2_1 VNB VPB VGND VPWR A Y B
X0 VPWR A Y VPB sky130_fd_pr__pfet_01v8_hvt ad=0.26 pd=2.52 as=0.135 ps=1.27 w=1 l=0.15
X1 Y A a_113_47# VNB sky130_fd_pr__nfet_01v8 ad=0.169 pd=1.82 as=0.08775 ps=0.92 w=0.65 l=0.15
X2 a_113_47# B VGND VNB sky130_fd_pr__nfet_01v8 ad=0.08775 pd=0.92 as=0.169 ps=1.82 w=0.65 l=0.15
X3 Y B VPWR VPB sky130_fd_pr__pfet_01v8_hvt ad=0.135 pd=1.27 as=0.26 ps=2.52 w=1 l=0.15
.ends

.subckt sky130_fd_sc_hd__decap_4 VNB VPB VGND VPWR
X0 VPWR VGND VPWR VPB sky130_fd_pr__pfet_01v8_hvt ad=0.2262 pd=2.26 as=0.4524 ps=4.52 w=0.87 l=1.05
X1 VGND VPWR VGND VNB sky130_fd_pr__nfet_01v8 ad=0.143 pd=1.62 as=0.286 ps=3.24 w=0.55 l=1.05
.ends

.subckt sky130_fd_sc_hd__decap_8 VNB VPB VPWR VGND
X0 VPWR VGND VPWR VPB sky130_fd_pr__pfet_01v8_hvt ad=0.2262 pd=2.26 as=0.4524 ps=4.52 w=0.87 l=2.89
X1 VGND VPWR VGND VNB sky130_fd_pr__nfet_01v8 ad=0.143 pd=1.62 as=0.286 ps=3.24 w=0.55 l=2.89
.ends

.subckt sky130_fd_sc_hd__a21oi_1 VNB VPB VPWR VGND A2 A1 B1 Y a_113_297#
X0 a_199_47# A1 Y VNB sky130_fd_pr__nfet_01v8 ad=0.09588 pd=0.945 as=0.091 ps=0.93 w=0.65 l=0.15
X1 a_113_297# A2 VPWR VPB sky130_fd_pr__pfet_01v8_hvt ad=0.265 pd=2.53 as=0.1475 ps=1.295 w=1 l=0.15
X2 Y B1 VGND VNB sky130_fd_pr__nfet_01v8 ad=0.091 pd=0.93 as=0.17225 ps=1.83 w=0.65 l=0.15
X3 VPWR A1 a_113_297# VPB sky130_fd_pr__pfet_01v8_hvt ad=0.1475 pd=1.295 as=0.14 ps=1.28 w=1 l=0.15
X4 a_113_297# B1 Y VPB sky130_fd_pr__pfet_01v8_hvt ad=0.14 pd=1.28 as=0.265 ps=2.53 w=1 l=0.15
X5 VGND A2 a_199_47# VNB sky130_fd_pr__nfet_01v8 ad=0.17225 pd=1.83 as=0.09588 ps=0.945 w=0.65 l=0.15
.ends

.subckt sky130_fd_sc_hd__or3_1 VNB VPB VPWR VGND B C A X a_29_53#
X0 X a_29_53# VPWR VPB sky130_fd_pr__pfet_01v8_hvt ad=0.28 pd=2.56 as=0.14825 ps=1.34 w=1 l=0.15
X1 a_111_297# C a_29_53# VPB sky130_fd_pr__pfet_01v8_hvt ad=0.0441 pd=0.63 as=0.1092 ps=1.36 w=0.42 l=0.15
X2 X a_29_53# VGND VNB sky130_fd_pr__nfet_01v8 ad=0.182 pd=1.86 as=0.10187 ps=0.99 w=0.65 l=0.15
X3 a_183_297# B a_111_297# VPB sky130_fd_pr__pfet_01v8_hvt ad=0.0693 pd=0.75 as=0.0441 ps=0.63 w=0.42 l=0.15
X4 VPWR A a_183_297# VPB sky130_fd_pr__pfet_01v8_hvt ad=0.14825 pd=1.34 as=0.0693 ps=0.75 w=0.42 l=0.15
X5 a_29_53# B VGND VNB sky130_fd_pr__nfet_01v8 ad=0.0567 pd=0.69 as=0.0567 ps=0.69 w=0.42 l=0.15
X6 VGND C a_29_53# VNB sky130_fd_pr__nfet_01v8 ad=0.0567 pd=0.69 as=0.1092 ps=1.36 w=0.42 l=0.15
X7 VGND A a_29_53# VNB sky130_fd_pr__nfet_01v8 ad=0.10187 pd=0.99 as=0.0567 ps=0.69 w=0.42 l=0.15
.ends

.subckt sky130_fd_sc_hd__lpflow_inputiso1p_1 VNB VPB VGND VPWR X SLEEP A a_68_297#
X0 VGND SLEEP a_68_297# VNB sky130_fd_pr__nfet_01v8 ad=0.10025 pd=0.985 as=0.0567 ps=0.69 w=0.42 l=0.15
X1 a_68_297# A VGND VNB sky130_fd_pr__nfet_01v8 ad=0.0567 pd=0.69 as=0.1092 ps=1.36 w=0.42 l=0.15
X2 X a_68_297# VGND VNB sky130_fd_pr__nfet_01v8 ad=0.169 pd=1.82 as=0.10025 ps=0.985 w=0.65 l=0.15
X3 VPWR SLEEP a_150_297# VPB sky130_fd_pr__pfet_01v8_hvt ad=0.14575 pd=1.335 as=0.0441 ps=0.63 w=0.42 l=0.15
X4 X a_68_297# VPWR VPB sky130_fd_pr__pfet_01v8_hvt ad=0.34 pd=2.68 as=0.14575 ps=1.335 w=1 l=0.15
X5 a_150_297# A a_68_297# VPB sky130_fd_pr__pfet_01v8_hvt ad=0.0441 pd=0.63 as=0.1092 ps=1.36 w=0.42 l=0.15
.ends

.subckt sky130_fd_sc_hd__nor3_1 VNB VPB VGND VPWR C B A Y
X0 VPWR A a_193_297# VPB sky130_fd_pr__pfet_01v8_hvt ad=0.26 pd=2.52 as=0.135 ps=1.27 w=1 l=0.15
X1 a_193_297# B a_109_297# VPB sky130_fd_pr__pfet_01v8_hvt ad=0.135 pd=1.27 as=0.135 ps=1.27 w=1 l=0.15
X2 Y B VGND VNB sky130_fd_pr__nfet_01v8 ad=0.08775 pd=0.92 as=0.08775 ps=0.92 w=0.65 l=0.15
X3 VGND A Y VNB sky130_fd_pr__nfet_01v8 ad=0.169 pd=1.82 as=0.08775 ps=0.92 w=0.65 l=0.15
X4 a_109_297# C Y VPB sky130_fd_pr__pfet_01v8_hvt ad=0.135 pd=1.27 as=0.26 ps=2.52 w=1 l=0.15
X5 VGND C Y VNB sky130_fd_pr__nfet_01v8 ad=0.08775 pd=0.92 as=0.169 ps=1.82 w=0.65 l=0.15
.ends

.subckt sky130_fd_sc_hd__xor2_1 VNB VPB VPWR VGND A X B a_285_297# a_35_297#
X0 X a_35_297# a_285_297# VPB sky130_fd_pr__pfet_01v8_hvt ad=0.3 pd=2.6 as=0.26 ps=2.52 w=1 l=0.15
X1 X B a_285_47# VNB sky130_fd_pr__nfet_01v8 ad=0.25025 pd=1.42 as=0.08775 ps=0.92 w=0.65 l=0.15
X2 a_35_297# B VGND VNB sky130_fd_pr__nfet_01v8 ad=0.08775 pd=0.92 as=0.169 ps=1.82 w=0.65 l=0.15
X3 a_117_297# B a_35_297# VPB sky130_fd_pr__pfet_01v8_hvt ad=0.135 pd=1.27 as=0.26 ps=2.52 w=1 l=0.15
X4 VPWR B a_285_297# VPB sky130_fd_pr__pfet_01v8_hvt ad=0.26 pd=2.52 as=0.135 ps=1.27 w=1 l=0.15
X5 VGND A a_35_297# VNB sky130_fd_pr__nfet_01v8 ad=0.08775 pd=0.92 as=0.08775 ps=0.92 w=0.65 l=0.15
X6 VGND a_35_297# X VNB sky130_fd_pr__nfet_01v8 ad=0.208 pd=1.94 as=0.25025 ps=1.42 w=0.65 l=0.15
X7 a_285_297# A VPWR VPB sky130_fd_pr__pfet_01v8_hvt ad=0.135 pd=1.27 as=0.135 ps=1.27 w=1 l=0.15
X8 VPWR A a_117_297# VPB sky130_fd_pr__pfet_01v8_hvt ad=0.135 pd=1.27 as=0.135 ps=1.27 w=1 l=0.15
X9 a_285_47# A VGND VNB sky130_fd_pr__nfet_01v8 ad=0.08775 pd=0.92 as=0.08775 ps=0.92 w=0.65 l=0.15
.ends

.subckt sky130_fd_sc_hd__and3_1 VNB VPB VGND VPWR X C B A a_27_47#
X0 VPWR A a_27_47# VPB sky130_fd_pr__pfet_01v8_hvt ad=0.0567 pd=0.69 as=0.1092 ps=1.36 w=0.42 l=0.15
X1 VPWR C a_27_47# VPB sky130_fd_pr__pfet_01v8_hvt ad=0.14222 pd=1.335 as=0.06615 ps=0.735 w=0.42 l=0.15
X2 a_181_47# B a_109_47# VNB sky130_fd_pr__nfet_01v8 ad=0.0441 pd=0.63 as=0.0441 ps=0.63 w=0.42 l=0.15
X3 VGND C a_181_47# VNB sky130_fd_pr__nfet_01v8 ad=0.13165 pd=1.14 as=0.0441 ps=0.63 w=0.42 l=0.15
X4 a_27_47# B VPWR VPB sky130_fd_pr__pfet_01v8_hvt ad=0.06615 pd=0.735 as=0.0567 ps=0.69 w=0.42 l=0.15
X5 X a_27_47# VPWR VPB sky130_fd_pr__pfet_01v8_hvt ad=0.26 pd=2.52 as=0.14222 ps=1.335 w=1 l=0.15
X6 X a_27_47# VGND VNB sky130_fd_pr__nfet_01v8 ad=0.169 pd=1.82 as=0.13165 ps=1.14 w=0.65 l=0.15
X7 a_109_47# A a_27_47# VNB sky130_fd_pr__nfet_01v8 ad=0.0441 pd=0.63 as=0.1092 ps=1.36 w=0.42 l=0.15
.ends

.subckt sky130_fd_sc_hd__clkinvlp_4 VNB VPB VPWR VGND A Y
X0 Y A VPWR VPB sky130_fd_pr__pfet_01v8_hvt ad=0.14 pd=1.28 as=0.265 ps=2.53 w=1 l=0.25
X1 VGND A a_268_47# VNB sky130_fd_pr__nfet_01v8 ad=0.14575 pd=1.63 as=0.05775 ps=0.76 w=0.55 l=0.15
X2 Y A VPWR VPB sky130_fd_pr__pfet_01v8_hvt ad=0.14 pd=1.28 as=0.14 ps=1.28 w=1 l=0.25
X3 Y A a_110_47# VNB sky130_fd_pr__nfet_01v8 ad=0.077 pd=0.83 as=0.05775 ps=0.76 w=0.55 l=0.15
X4 VPWR A Y VPB sky130_fd_pr__pfet_01v8_hvt ad=0.14 pd=1.28 as=0.14 ps=1.28 w=1 l=0.25
X5 a_110_47# A VGND VNB sky130_fd_pr__nfet_01v8 ad=0.05775 pd=0.76 as=0.14575 ps=1.63 w=0.55 l=0.15
X6 a_268_47# A Y VNB sky130_fd_pr__nfet_01v8 ad=0.05775 pd=0.76 as=0.077 ps=0.83 w=0.55 l=0.15
X7 VPWR A Y VPB sky130_fd_pr__pfet_01v8_hvt ad=0.265 pd=2.53 as=0.14 ps=1.28 w=1 l=0.25
.ends

.subckt sky130_fd_sc_hd__a22oi_1 VNB VPB VPWR VGND B2 B1 Y A1 A2 a_381_47# a_109_297#
X0 Y B1 a_109_47# VNB sky130_fd_pr__nfet_01v8 ad=0.169 pd=1.82 as=0.07475 ps=0.88 w=0.65 l=0.15
X1 Y B1 a_109_297# VPB sky130_fd_pr__pfet_01v8_hvt ad=0.26 pd=2.52 as=0.135 ps=1.27 w=1 l=0.15
X2 VPWR A2 a_109_297# VPB sky130_fd_pr__pfet_01v8_hvt ad=0.3 pd=2.6 as=0.135 ps=1.27 w=1 l=0.15
X3 a_109_297# A1 VPWR VPB sky130_fd_pr__pfet_01v8_hvt ad=0.135 pd=1.27 as=0.26 ps=2.52 w=1 l=0.15
X4 a_381_47# A1 Y VNB sky130_fd_pr__nfet_01v8 ad=0.06825 pd=0.86 as=0.169 ps=1.82 w=0.65 l=0.15
X5 a_109_297# B2 Y VPB sky130_fd_pr__pfet_01v8_hvt ad=0.135 pd=1.27 as=0.26 ps=2.52 w=1 l=0.15
X6 a_109_47# B2 VGND VNB sky130_fd_pr__nfet_01v8 ad=0.07475 pd=0.88 as=0.169 ps=1.82 w=0.65 l=0.15
X7 VGND A2 a_381_47# VNB sky130_fd_pr__nfet_01v8 ad=0.234 pd=2.02 as=0.06825 ps=0.86 w=0.65 l=0.15
.ends

.subckt sky130_fd_sc_hd__buf_8 VNB VPB VGND VPWR A X a_27_47#
X0 X a_27_47# VGND VNB sky130_fd_pr__nfet_01v8 ad=0.08775 pd=0.92 as=0.08775 ps=0.92 w=0.65 l=0.15
X1 X a_27_47# VGND VNB sky130_fd_pr__nfet_01v8 ad=0.08775 pd=0.92 as=0.08775 ps=0.92 w=0.65 l=0.15
X2 X a_27_47# VGND VNB sky130_fd_pr__nfet_01v8 ad=0.08775 pd=0.92 as=0.08775 ps=0.92 w=0.65 l=0.15
X3 VPWR a_27_47# X VPB sky130_fd_pr__pfet_01v8_hvt ad=0.135 pd=1.27 as=0.135 ps=1.27 w=1 l=0.15
X4 X a_27_47# VPWR VPB sky130_fd_pr__pfet_01v8_hvt ad=0.135 pd=1.27 as=0.135 ps=1.27 w=1 l=0.15
X5 VGND a_27_47# X VNB sky130_fd_pr__nfet_01v8 ad=0.169 pd=1.82 as=0.08775 ps=0.92 w=0.65 l=0.15
X6 VPWR A a_27_47# VPB sky130_fd_pr__pfet_01v8_hvt ad=0.135 pd=1.27 as=0.135 ps=1.27 w=1 l=0.15
X7 VPWR a_27_47# X VPB sky130_fd_pr__pfet_01v8_hvt ad=0.26 pd=2.52 as=0.135 ps=1.27 w=1 l=0.15
X8 a_27_47# A VPWR VPB sky130_fd_pr__pfet_01v8_hvt ad=0.135 pd=1.27 as=0.135 ps=1.27 w=1 l=0.15
X9 X a_27_47# VPWR VPB sky130_fd_pr__pfet_01v8_hvt ad=0.135 pd=1.27 as=0.135 ps=1.27 w=1 l=0.15
X10 a_27_47# A VGND VNB sky130_fd_pr__nfet_01v8 ad=0.08775 pd=0.92 as=0.08775 ps=0.92 w=0.65 l=0.15
X11 X a_27_47# VGND VNB sky130_fd_pr__nfet_01v8 ad=0.08775 pd=0.92 as=0.08775 ps=0.92 w=0.65 l=0.15
X12 VPWR a_27_47# X VPB sky130_fd_pr__pfet_01v8_hvt ad=0.135 pd=1.27 as=0.135 ps=1.27 w=1 l=0.15
X13 X a_27_47# VPWR VPB sky130_fd_pr__pfet_01v8_hvt ad=0.135 pd=1.27 as=0.135 ps=1.27 w=1 l=0.15
X14 VGND A a_27_47# VNB sky130_fd_pr__nfet_01v8 ad=0.08775 pd=0.92 as=0.08775 ps=0.92 w=0.65 l=0.15
X15 VGND a_27_47# X VNB sky130_fd_pr__nfet_01v8 ad=0.08775 pd=0.92 as=0.08775 ps=0.92 w=0.65 l=0.15
X16 VPWR a_27_47# X VPB sky130_fd_pr__pfet_01v8_hvt ad=0.135 pd=1.27 as=0.135 ps=1.27 w=1 l=0.15
X17 VGND a_27_47# X VNB sky130_fd_pr__nfet_01v8 ad=0.08775 pd=0.92 as=0.08775 ps=0.92 w=0.65 l=0.15
X18 VGND a_27_47# X VNB sky130_fd_pr__nfet_01v8 ad=0.08775 pd=0.92 as=0.08775 ps=0.92 w=0.65 l=0.15
X19 X a_27_47# VPWR VPB sky130_fd_pr__pfet_01v8_hvt ad=0.135 pd=1.27 as=0.135 ps=1.27 w=1 l=0.15
X20 VPWR A a_27_47# VPB sky130_fd_pr__pfet_01v8_hvt ad=0.135 pd=1.27 as=0.26 ps=2.52 w=1 l=0.15
X21 VGND A a_27_47# VNB sky130_fd_pr__nfet_01v8 ad=0.08775 pd=0.92 as=0.169 ps=1.82 w=0.65 l=0.15
.ends

.subckt sky130_fd_sc_hd__o31a_1 VNB VPB VGND VPWR X A1 A2 A3 B1 a_103_199# a_253_47#
X0 a_103_199# B1 a_253_47# VNB sky130_fd_pr__nfet_01v8 ad=0.2015 pd=1.92 as=0.10725 ps=0.98 w=0.65 l=0.15
X1 VPWR a_103_199# X VPB sky130_fd_pr__pfet_01v8_hvt ad=0.195 pd=1.39 as=0.36 ps=2.72 w=1 l=0.15
X2 a_337_297# A2 a_253_297# VPB sky130_fd_pr__pfet_01v8_hvt ad=0.165 pd=1.33 as=0.135 ps=1.27 w=1 l=0.15
X3 a_103_199# A3 a_337_297# VPB sky130_fd_pr__pfet_01v8_hvt ad=0.2125 pd=1.425 as=0.165 ps=1.33 w=1 l=0.15
X4 a_253_297# A1 VPWR VPB sky130_fd_pr__pfet_01v8_hvt ad=0.135 pd=1.27 as=0.195 ps=1.39 w=1 l=0.15
X5 VPWR B1 a_103_199# VPB sky130_fd_pr__pfet_01v8_hvt ad=0.345 pd=2.69 as=0.2125 ps=1.425 w=1 l=0.15
X6 VGND a_103_199# X VNB sky130_fd_pr__nfet_01v8 ad=0.12675 pd=1.04 as=0.234 ps=2.02 w=0.65 l=0.15
X7 a_253_47# A1 VGND VNB sky130_fd_pr__nfet_01v8 ad=0.08775 pd=0.92 as=0.12675 ps=1.04 w=0.65 l=0.15
X8 a_253_47# A3 VGND VNB sky130_fd_pr__nfet_01v8 ad=0.10725 pd=0.98 as=0.10725 ps=0.98 w=0.65 l=0.15
X9 VGND A2 a_253_47# VNB sky130_fd_pr__nfet_01v8 ad=0.10725 pd=0.98 as=0.08775 ps=0.92 w=0.65 l=0.15
.ends

.subckt sky130_fd_sc_hd__dfrtp_1 VNB VPB VGND VPWR CLK D RESET_B Q a_543_47# a_651_413#
+ a_193_47# a_448_47# a_1283_21# a_761_289# a_1108_47# a_27_47#
X0 a_805_47# a_761_289# a_639_47# VNB sky130_fd_pr__nfet_01v8 ad=0.0441 pd=0.63 as=0.1401 ps=1.1 w=0.42 l=0.15
X1 a_1217_47# a_27_47# a_1108_47# VNB sky130_fd_pr__special_nfet_01v8 ad=0.0669 pd=0.75 as=0.0711 ps=0.755 w=0.36 l=0.15
X2 a_1283_21# a_1108_47# a_1462_47# VNB sky130_fd_pr__nfet_01v8 ad=0.1092 pd=1.36 as=0.06405 ps=0.725 w=0.42 l=0.15
X3 a_651_413# a_27_47# a_543_47# VPB sky130_fd_pr__pfet_01v8_hvt ad=0.1155 pd=0.97 as=0.07245 ps=0.765 w=0.42 l=0.15
X4 a_1108_47# a_193_47# a_761_289# VNB sky130_fd_pr__special_nfet_01v8 ad=0.0711 pd=0.755 as=0.0999 ps=0.985 w=0.36 l=0.15
X5 VGND RESET_B a_805_47# VNB sky130_fd_pr__nfet_01v8 ad=0.1346 pd=1.15 as=0.0441 ps=0.63 w=0.42 l=0.15
X6 Q a_1283_21# VPWR VPB sky130_fd_pr__pfet_01v8_hvt ad=0.26 pd=2.52 as=0.3012 ps=2.66 w=1 l=0.15
X7 VPWR CLK a_27_47# VPB sky130_fd_pr__pfet_01v8_hvt ad=0.0864 pd=0.91 as=0.1664 ps=1.8 w=0.64 l=0.15
X8 a_448_47# D VPWR VPB sky130_fd_pr__pfet_01v8_hvt ad=0.0651 pd=0.73 as=0.1092 ps=1.36 w=0.42 l=0.15
X9 a_761_289# a_543_47# VGND VNB sky130_fd_pr__nfet_01v8 ad=0.0999 pd=0.985 as=0.1346 ps=1.15 w=0.64 l=0.15
X10 a_193_47# a_27_47# VGND VNB sky130_fd_pr__nfet_01v8 ad=0.1092 pd=1.36 as=0.0567 ps=0.69 w=0.42 l=0.15
X11 a_1108_47# a_27_47# a_761_289# VPB sky130_fd_pr__pfet_01v8_hvt ad=0.0588 pd=0.7 as=0.12915 ps=1.185 w=0.42 l=0.15
X12 a_1462_47# RESET_B VGND VNB sky130_fd_pr__nfet_01v8 ad=0.06405 pd=0.725 as=0.12495 ps=1.015 w=0.42 l=0.15
X13 a_543_47# a_27_47# a_448_47# VNB sky130_fd_pr__special_nfet_01v8 ad=0.0594 pd=0.69 as=0.066 ps=0.745 w=0.36 l=0.15
X14 a_543_47# a_193_47# a_448_47# VPB sky130_fd_pr__pfet_01v8_hvt ad=0.07245 pd=0.765 as=0.0651 ps=0.73 w=0.42 l=0.15
X15 a_448_47# D VGND VNB sky130_fd_pr__nfet_01v8 ad=0.066 pd=0.745 as=0.2205 ps=1.89 w=0.42 l=0.15
X16 VPWR a_1283_21# a_1270_413# VPB sky130_fd_pr__pfet_01v8_hvt ad=0.0819 pd=0.81 as=0.0567 ps=0.69 w=0.42 l=0.15
X17 VPWR a_1108_47# a_1283_21# VPB sky130_fd_pr__pfet_01v8_hvt ad=0.1134 pd=1.38 as=0.0567 ps=0.69 w=0.42 l=0.15
X18 a_1270_413# a_193_47# a_1108_47# VPB sky130_fd_pr__pfet_01v8_hvt ad=0.0567 pd=0.69 as=0.0588 ps=0.7 w=0.42 l=0.15
X19 a_193_47# a_27_47# VPWR VPB sky130_fd_pr__pfet_01v8_hvt ad=0.1664 pd=1.8 as=0.0864 ps=0.91 w=0.64 l=0.15
X20 a_1283_21# RESET_B VPWR VPB sky130_fd_pr__pfet_01v8_hvt ad=0.0567 pd=0.69 as=0.0819 ps=0.81 w=0.42 l=0.15
X21 VPWR a_761_289# a_651_413# VPB sky130_fd_pr__pfet_01v8_hvt ad=0.07035 pd=0.755 as=0.1155 ps=0.97 w=0.42 l=0.15
X22 Q a_1283_21# VGND VNB sky130_fd_pr__nfet_01v8 ad=0.169 pd=1.82 as=0.2087 ps=2.02 w=0.65 l=0.15
X23 a_639_47# a_193_47# a_543_47# VNB sky130_fd_pr__special_nfet_01v8 ad=0.1401 pd=1.1 as=0.0594 ps=0.69 w=0.36 l=0.15
X24 VGND a_1283_21# a_1217_47# VNB sky130_fd_pr__nfet_01v8 ad=0.12495 pd=1.015 as=0.0669 ps=0.75 w=0.42 l=0.15
X25 a_651_413# RESET_B VPWR VPB sky130_fd_pr__pfet_01v8_hvt ad=0.1092 pd=1.36 as=0.07035 ps=0.755 w=0.42 l=0.15
X26 VGND CLK a_27_47# VNB sky130_fd_pr__nfet_01v8 ad=0.0567 pd=0.69 as=0.1092 ps=1.36 w=0.42 l=0.15
X27 a_761_289# a_543_47# VPWR VPB sky130_fd_pr__pfet_01v8_hvt ad=0.12915 pd=1.185 as=0.2184 ps=2.2 w=0.84 l=0.15
.ends

.subckt sky130_fd_sc_hd__o21a_1 VNB VPB VGND VPWR A1 A2 B1 X a_297_47# a_79_21#
X0 VPWR A1 a_382_297# VPB sky130_fd_pr__pfet_01v8_hvt ad=0.26 pd=2.52 as=0.1525 ps=1.305 w=1 l=0.15
X1 a_297_47# B1 a_79_21# VNB sky130_fd_pr__nfet_01v8 ad=0.10075 pd=0.96 as=0.169 ps=1.82 w=0.65 l=0.15
X2 a_297_47# A1 VGND VNB sky130_fd_pr__nfet_01v8 ad=0.169 pd=1.82 as=0.08775 ps=0.92 w=0.65 l=0.15
X3 VGND A2 a_297_47# VNB sky130_fd_pr__nfet_01v8 ad=0.08775 pd=0.92 as=0.10075 ps=0.96 w=0.65 l=0.15
X4 VPWR a_79_21# X VPB sky130_fd_pr__pfet_01v8_hvt ad=0.3275 pd=1.655 as=0.28 ps=2.56 w=1 l=0.15
X5 a_79_21# B1 VPWR VPB sky130_fd_pr__pfet_01v8_hvt ad=0.195 pd=1.39 as=0.3275 ps=1.655 w=1 l=0.15
X6 a_382_297# A2 a_79_21# VPB sky130_fd_pr__pfet_01v8_hvt ad=0.1525 pd=1.305 as=0.195 ps=1.39 w=1 l=0.15
X7 VGND a_79_21# X VNB sky130_fd_pr__nfet_01v8 ad=0.169 pd=1.82 as=0.169 ps=1.82 w=0.65 l=0.15
.ends

.subckt sky130_fd_sc_hd__nand4_1 VNB VPB VPWR VGND A C D Y B
X0 Y B VPWR VPB sky130_fd_pr__pfet_01v8_hvt ad=0.165 pd=1.33 as=0.135 ps=1.27 w=1 l=0.15
X1 VPWR A Y VPB sky130_fd_pr__pfet_01v8_hvt ad=0.3 pd=2.6 as=0.165 ps=1.33 w=1 l=0.15
X2 VPWR C Y VPB sky130_fd_pr__pfet_01v8_hvt ad=0.135 pd=1.27 as=0.135 ps=1.27 w=1 l=0.15
X3 a_193_47# C a_109_47# VNB sky130_fd_pr__nfet_01v8 ad=0.08775 pd=0.92 as=0.08775 ps=0.92 w=0.65 l=0.15
X4 Y A a_277_47# VNB sky130_fd_pr__nfet_01v8 ad=0.195 pd=1.9 as=0.10725 ps=0.98 w=0.65 l=0.15
X5 a_277_47# B a_193_47# VNB sky130_fd_pr__nfet_01v8 ad=0.10725 pd=0.98 as=0.08775 ps=0.92 w=0.65 l=0.15
X6 Y D VPWR VPB sky130_fd_pr__pfet_01v8_hvt ad=0.135 pd=1.27 as=0.26 ps=2.52 w=1 l=0.15
X7 a_109_47# D VGND VNB sky130_fd_pr__nfet_01v8 ad=0.08775 pd=0.92 as=0.169 ps=1.82 w=0.65 l=0.15
.ends

.subckt sky130_fd_sc_hd__nor2_1 VNB VPB VGND VPWR A B Y
X0 VPWR A a_109_297# VPB sky130_fd_pr__pfet_01v8_hvt ad=0.26 pd=2.52 as=0.105 ps=1.21 w=1 l=0.15
X1 VGND A Y VNB sky130_fd_pr__nfet_01v8 ad=0.169 pd=1.82 as=0.08775 ps=0.92 w=0.65 l=0.15
X2 a_109_297# B Y VPB sky130_fd_pr__pfet_01v8_hvt ad=0.105 pd=1.21 as=0.26 ps=2.52 w=1 l=0.15
X3 Y B VGND VNB sky130_fd_pr__nfet_01v8 ad=0.08775 pd=0.92 as=0.169 ps=1.82 w=0.65 l=0.15
.ends

.subckt sky130_fd_sc_hd__xnor2_1 VNB VPB VGND VPWR B A Y a_47_47# a_285_47# a_377_297#
X0 a_377_297# A VPWR VPB sky130_fd_pr__pfet_01v8_hvt ad=0.105 pd=1.21 as=0.365 ps=1.73 w=1 l=0.15
X1 a_47_47# B VPWR VPB sky130_fd_pr__pfet_01v8_hvt ad=0.135 pd=1.27 as=0.3 ps=2.6 w=1 l=0.15
X2 a_129_47# B a_47_47# VNB sky130_fd_pr__nfet_01v8 ad=0.06825 pd=0.86 as=0.169 ps=1.82 w=0.65 l=0.15
X3 a_285_47# B VGND VNB sky130_fd_pr__nfet_01v8 ad=0.08775 pd=0.92 as=0.169 ps=1.82 w=0.65 l=0.15
X4 Y a_47_47# a_285_47# VNB sky130_fd_pr__nfet_01v8 ad=0.195 pd=1.9 as=0.08775 ps=0.92 w=0.65 l=0.15
X5 VGND A a_129_47# VNB sky130_fd_pr__nfet_01v8 ad=0.08775 pd=0.92 as=0.06825 ps=0.86 w=0.65 l=0.15
X6 VPWR A a_47_47# VPB sky130_fd_pr__pfet_01v8_hvt ad=0.365 pd=1.73 as=0.135 ps=1.27 w=1 l=0.15
X7 VPWR a_47_47# Y VPB sky130_fd_pr__pfet_01v8_hvt ad=0.36 pd=2.72 as=0.165 ps=1.33 w=1 l=0.15
X8 Y B a_377_297# VPB sky130_fd_pr__pfet_01v8_hvt ad=0.165 pd=1.33 as=0.105 ps=1.21 w=1 l=0.15
X9 a_285_47# A VGND VNB sky130_fd_pr__nfet_01v8 ad=0.169 pd=1.82 as=0.08775 ps=0.92 w=0.65 l=0.15
.ends

.subckt sky130_fd_sc_hd__clkbuf_4 VNB VPB VGND VPWR A X a_27_47#
X0 VPWR A a_27_47# VPB sky130_fd_pr__pfet_01v8_hvt ad=0.165 pd=1.33 as=0.265 ps=2.53 w=1 l=0.15
X1 VGND a_27_47# X VNB sky130_fd_pr__nfet_01v8 ad=0.1218 pd=1.42 as=0.0588 ps=0.7 w=0.42 l=0.15
X2 VGND a_27_47# X VNB sky130_fd_pr__nfet_01v8 ad=0.0588 pd=0.7 as=0.0588 ps=0.7 w=0.42 l=0.15
X3 X a_27_47# VPWR VPB sky130_fd_pr__pfet_01v8_hvt ad=0.14 pd=1.28 as=0.14 ps=1.28 w=1 l=0.15
X4 X a_27_47# VGND VNB sky130_fd_pr__nfet_01v8 ad=0.0588 pd=0.7 as=0.0588 ps=0.7 w=0.42 l=0.15
X5 VGND A a_27_47# VNB sky130_fd_pr__nfet_01v8 ad=0.07035 pd=0.755 as=0.1113 ps=1.37 w=0.42 l=0.15
X6 VPWR a_27_47# X VPB sky130_fd_pr__pfet_01v8_hvt ad=0.3 pd=2.6 as=0.14 ps=1.28 w=1 l=0.15
X7 X a_27_47# VGND VNB sky130_fd_pr__nfet_01v8 ad=0.0588 pd=0.7 as=0.07035 ps=0.755 w=0.42 l=0.15
X8 X a_27_47# VPWR VPB sky130_fd_pr__pfet_01v8_hvt ad=0.14 pd=1.28 as=0.165 ps=1.33 w=1 l=0.15
X9 VPWR a_27_47# X VPB sky130_fd_pr__pfet_01v8_hvt ad=0.14 pd=1.28 as=0.14 ps=1.28 w=1 l=0.15
.ends

.subckt sky130_fd_sc_hd__inv_6 VNB VPB VPWR VGND Y A
X0 VPWR A Y VPB sky130_fd_pr__pfet_01v8_hvt ad=0.27 pd=2.54 as=0.135 ps=1.27 w=1 l=0.15
X1 Y A VPWR VPB sky130_fd_pr__pfet_01v8_hvt ad=0.135 pd=1.27 as=0.135 ps=1.27 w=1 l=0.15
X2 Y A VGND VNB sky130_fd_pr__nfet_01v8 ad=0.08775 pd=0.92 as=0.08775 ps=0.92 w=0.65 l=0.15
X3 VPWR A Y VPB sky130_fd_pr__pfet_01v8_hvt ad=0.135 pd=1.27 as=0.135 ps=1.27 w=1 l=0.15
X4 Y A VPWR VPB sky130_fd_pr__pfet_01v8_hvt ad=0.135 pd=1.27 as=0.135 ps=1.27 w=1 l=0.15
X5 VPWR A Y VPB sky130_fd_pr__pfet_01v8_hvt ad=0.135 pd=1.27 as=0.135 ps=1.27 w=1 l=0.15
X6 Y A VGND VNB sky130_fd_pr__nfet_01v8 ad=0.08775 pd=0.92 as=0.247 ps=2.06 w=0.65 l=0.15
X7 Y A VGND VNB sky130_fd_pr__nfet_01v8 ad=0.08775 pd=0.92 as=0.08775 ps=0.92 w=0.65 l=0.15
X8 Y A VPWR VPB sky130_fd_pr__pfet_01v8_hvt ad=0.135 pd=1.27 as=0.43 ps=2.86 w=1 l=0.15
X9 VGND A Y VNB sky130_fd_pr__nfet_01v8 ad=0.08775 pd=0.92 as=0.08775 ps=0.92 w=0.65 l=0.15
X10 VGND A Y VNB sky130_fd_pr__nfet_01v8 ad=0.08775 pd=0.92 as=0.08775 ps=0.92 w=0.65 l=0.15
X11 VGND A Y VNB sky130_fd_pr__nfet_01v8 ad=0.1755 pd=1.84 as=0.08775 ps=0.92 w=0.65 l=0.15
.ends

.subckt sky130_fd_sc_hd__and2_1 VNB VPB VPWR VGND X A B a_59_75#
X0 VPWR B a_59_75# VPB sky130_fd_pr__pfet_01v8_hvt ad=0.16655 pd=1.39 as=0.0567 ps=0.69 w=0.42 l=0.15
X1 X a_59_75# VPWR VPB sky130_fd_pr__pfet_01v8_hvt ad=0.475 pd=2.95 as=0.16655 ps=1.39 w=1 l=0.15
X2 VGND B a_145_75# VNB sky130_fd_pr__nfet_01v8 ad=0.1118 pd=1.04 as=0.0567 ps=0.69 w=0.42 l=0.15
X3 a_59_75# A VPWR VPB sky130_fd_pr__pfet_01v8_hvt ad=0.0567 pd=0.69 as=0.1176 ps=1.4 w=0.42 l=0.15
X4 X a_59_75# VGND VNB sky130_fd_pr__nfet_01v8 ad=0.182 pd=1.86 as=0.1118 ps=1.04 w=0.65 l=0.15
X5 a_145_75# A a_59_75# VNB sky130_fd_pr__nfet_01v8 ad=0.0567 pd=0.69 as=0.1176 ps=1.4 w=0.42 l=0.15
.ends

.subckt sky130_fd_sc_hd__nor4b_1 VNB VPB VGND VPWR D_N C Y B A a_91_199#
X0 Y a_91_199# VGND VNB sky130_fd_pr__nfet_01v8 ad=0.08775 pd=0.92 as=0.182 ps=1.86 w=0.65 l=0.15
X1 Y B VGND VNB sky130_fd_pr__nfet_01v8 ad=0.08775 pd=0.92 as=0.10725 ps=0.98 w=0.65 l=0.15
X2 VGND C Y VNB sky130_fd_pr__nfet_01v8 ad=0.10725 pd=0.98 as=0.08775 ps=0.92 w=0.65 l=0.15
X3 a_91_199# D_N VGND VNB sky130_fd_pr__nfet_01v8 ad=0.1092 pd=1.36 as=0.10025 ps=0.985 w=0.42 l=0.15
X4 VGND A Y VNB sky130_fd_pr__nfet_01v8 ad=0.10025 pd=0.985 as=0.08775 ps=0.92 w=0.65 l=0.15
X5 VPWR A a_341_297# VPB sky130_fd_pr__pfet_01v8_hvt ad=0.14575 pd=1.335 as=0.135 ps=1.27 w=1 l=0.15
X6 a_245_297# C a_161_297# VPB sky130_fd_pr__pfet_01v8_hvt ad=0.165 pd=1.33 as=0.135 ps=1.27 w=1 l=0.15
X7 a_341_297# B a_245_297# VPB sky130_fd_pr__pfet_01v8_hvt ad=0.135 pd=1.27 as=0.165 ps=1.33 w=1 l=0.15
X8 a_91_199# D_N VPWR VPB sky130_fd_pr__pfet_01v8_hvt ad=0.1092 pd=1.36 as=0.14575 ps=1.335 w=0.42 l=0.15
X9 a_161_297# a_91_199# Y VPB sky130_fd_pr__pfet_01v8_hvt ad=0.135 pd=1.27 as=0.52 ps=3.04 w=1 l=0.15
.ends

.subckt sky130_fd_sc_hd__o22ai_1 VNB VPB VGND VPWR A1 A2 B1 B2 Y a_27_47#
X0 VGND A2 a_27_47# VNB sky130_fd_pr__nfet_01v8 ad=0.08775 pd=0.92 as=0.11537 ps=1.005 w=0.65 l=0.15
X1 a_27_47# B2 Y VNB sky130_fd_pr__nfet_01v8 ad=0.11537 pd=1.005 as=0.09262 ps=0.935 w=0.65 l=0.15
X2 VPWR A1 a_307_297# VPB sky130_fd_pr__pfet_01v8_hvt ad=0.27 pd=2.54 as=0.105 ps=1.21 w=1 l=0.15
X3 a_307_297# A2 Y VPB sky130_fd_pr__pfet_01v8_hvt ad=0.105 pd=1.21 as=0.2325 ps=1.465 w=1 l=0.15
X4 a_27_47# A1 VGND VNB sky130_fd_pr__nfet_01v8 ad=0.169 pd=1.82 as=0.08775 ps=0.92 w=0.65 l=0.15
X5 Y B2 a_109_297# VPB sky130_fd_pr__pfet_01v8_hvt ad=0.2325 pd=1.465 as=0.1125 ps=1.225 w=1 l=0.15
X6 a_109_297# B1 VPWR VPB sky130_fd_pr__pfet_01v8_hvt ad=0.1125 pd=1.225 as=0.26 ps=2.52 w=1 l=0.15
X7 Y B1 a_27_47# VNB sky130_fd_pr__nfet_01v8 ad=0.09262 pd=0.935 as=0.169 ps=1.82 w=0.65 l=0.15
.ends

.subckt sky130_fd_sc_hd__a21boi_0 VNB VPB VPWR VGND A1 A2 B1_N Y a_300_369# a_27_47#
X0 a_300_369# A2 VPWR VPB sky130_fd_pr__pfet_01v8_hvt ad=0.1696 pd=1.81 as=0.0896 ps=0.92 w=0.64 l=0.15
X1 a_400_47# A1 Y VNB sky130_fd_pr__nfet_01v8 ad=0.0441 pd=0.63 as=0.1113 ps=0.95 w=0.42 l=0.15
X2 VGND A2 a_400_47# VNB sky130_fd_pr__nfet_01v8 ad=0.1113 pd=1.37 as=0.0441 ps=0.63 w=0.42 l=0.15
X3 VGND B1_N a_27_47# VNB sky130_fd_pr__nfet_01v8 ad=0.1302 pd=1.04 as=0.1113 ps=1.37 w=0.42 l=0.15
X4 VPWR B1_N a_27_47# VPB sky130_fd_pr__pfet_01v8_hvt ad=0.1113 pd=1.37 as=0.1113 ps=1.37 w=0.42 l=0.15
X5 Y a_27_47# VGND VNB sky130_fd_pr__nfet_01v8 ad=0.1113 pd=0.95 as=0.1302 ps=1.04 w=0.42 l=0.15
X6 a_300_369# a_27_47# Y VPB sky130_fd_pr__pfet_01v8_hvt ad=0.0896 pd=0.92 as=0.1696 ps=1.81 w=0.64 l=0.15
X7 VPWR A1 a_300_369# VPB sky130_fd_pr__pfet_01v8_hvt ad=0.0896 pd=0.92 as=0.0896 ps=0.92 w=0.64 l=0.15
.ends

.subckt sky130_fd_sc_hd__lpflow_isobufsrc_1 VNB VPB VGND VPWR A SLEEP X a_74_47#
X0 X a_74_47# a_265_297# VPB sky130_fd_pr__pfet_01v8_hvt ad=0.26 pd=2.52 as=0.105 ps=1.21 w=1 l=0.15
X1 VPWR A a_74_47# VPB sky130_fd_pr__pfet_01v8_hvt ad=0.1573 pd=1.39 as=0.1092 ps=1.36 w=0.42 l=0.15
X2 a_265_297# SLEEP VPWR VPB sky130_fd_pr__pfet_01v8_hvt ad=0.105 pd=1.21 as=0.1573 ps=1.39 w=1 l=0.15
X3 X SLEEP VGND VNB sky130_fd_pr__nfet_01v8 ad=0.08775 pd=0.92 as=0.10025 ps=0.985 w=0.65 l=0.15
X4 VGND A a_74_47# VNB sky130_fd_pr__nfet_01v8 ad=0.10025 pd=0.985 as=0.1092 ps=1.36 w=0.42 l=0.15
X5 VGND a_74_47# X VNB sky130_fd_pr__nfet_01v8 ad=0.169 pd=1.82 as=0.08775 ps=0.92 w=0.65 l=0.15
.ends

.subckt sky130_fd_sc_hd__nand3_1 VNB VPB VGND VPWR A B Y C
X0 VPWR B Y VPB sky130_fd_pr__pfet_01v8_hvt ad=0.165 pd=1.33 as=0.135 ps=1.27 w=1 l=0.15
X1 Y A VPWR VPB sky130_fd_pr__pfet_01v8_hvt ad=0.26 pd=2.52 as=0.165 ps=1.33 w=1 l=0.15
X2 a_193_47# B a_109_47# VNB sky130_fd_pr__nfet_01v8 ad=0.10725 pd=0.98 as=0.08775 ps=0.92 w=0.65 l=0.15
X3 Y A a_193_47# VNB sky130_fd_pr__nfet_01v8 ad=0.169 pd=1.82 as=0.10725 ps=0.98 w=0.65 l=0.15
X4 Y C VPWR VPB sky130_fd_pr__pfet_01v8_hvt ad=0.135 pd=1.27 as=0.26 ps=2.52 w=1 l=0.15
X5 a_109_47# C VGND VNB sky130_fd_pr__nfet_01v8 ad=0.08775 pd=0.92 as=0.169 ps=1.82 w=0.65 l=0.15
.ends

.subckt sky130_fd_sc_hd__o21ba_1 VNB VPB VGND VPWR B1_N A1 A2 X a_448_47# a_79_199#
+ a_222_93#
X0 a_222_93# B1_N VGND VNB sky130_fd_pr__nfet_01v8 ad=0.1092 pd=1.36 as=0.10025 ps=0.985 w=0.42 l=0.15
X1 VPWR A1 a_544_297# VPB sky130_fd_pr__pfet_01v8_hvt ad=0.28 pd=2.56 as=0.105 ps=1.21 w=1 l=0.15
X2 VGND a_79_199# X VNB sky130_fd_pr__nfet_01v8 ad=0.10025 pd=0.985 as=0.169 ps=1.82 w=0.65 l=0.15
X3 a_222_93# B1_N VPWR VPB sky130_fd_pr__pfet_01v8_hvt ad=0.1176 pd=1.4 as=0.18575 ps=1.415 w=0.42 l=0.15
X4 VGND A2 a_448_47# VNB sky130_fd_pr__nfet_01v8 ad=0.08775 pd=0.92 as=0.10725 ps=0.98 w=0.65 l=0.15
X5 a_448_47# a_222_93# a_79_199# VNB sky130_fd_pr__nfet_01v8 ad=0.10725 pd=0.98 as=0.169 ps=1.82 w=0.65 l=0.15
X6 a_79_199# a_222_93# VPWR VPB sky130_fd_pr__pfet_01v8_hvt ad=0.165 pd=1.33 as=0.3 ps=2.6 w=1 l=0.15
X7 a_544_297# A2 a_79_199# VPB sky130_fd_pr__pfet_01v8_hvt ad=0.105 pd=1.21 as=0.165 ps=1.33 w=1 l=0.15
X8 a_448_47# A1 VGND VNB sky130_fd_pr__nfet_01v8 ad=0.17225 pd=1.83 as=0.08775 ps=0.92 w=0.65 l=0.15
X9 VPWR a_79_199# X VPB sky130_fd_pr__pfet_01v8_hvt ad=0.18575 pd=1.415 as=0.26 ps=2.52 w=1 l=0.15
.ends

.subckt sky130_fd_sc_hd__conb_1 VNB VPB VGND VPWR LO HI a_21_232# a_159_232#
X0 VPWR HI sky130_fd_pr__res_generic_po w=0.48 l=0.5
X1 LO VGND sky130_fd_pr__res_generic_po w=0.48 l=0.5
.ends

.subckt sky130_fd_sc_hd__nor3b_1 VNB VPB VGND VPWR C_N B Y A a_91_199#
X0 VGND a_91_199# Y VNB sky130_fd_pr__nfet_01v8 ad=0.08775 pd=0.92 as=0.221 ps=1.98 w=0.65 l=0.15
X1 Y B VGND VNB sky130_fd_pr__nfet_01v8 ad=0.08775 pd=0.92 as=0.08775 ps=0.92 w=0.65 l=0.15
X2 VPWR A a_245_297# VPB sky130_fd_pr__pfet_01v8_hvt ad=0.14575 pd=1.335 as=0.135 ps=1.27 w=1 l=0.15
X3 a_91_199# C_N VGND VNB sky130_fd_pr__nfet_01v8 ad=0.1092 pd=1.36 as=0.10025 ps=0.985 w=0.42 l=0.15
X4 VGND A Y VNB sky130_fd_pr__nfet_01v8 ad=0.10025 pd=0.985 as=0.08775 ps=0.92 w=0.65 l=0.15
X5 a_245_297# B a_161_297# VPB sky130_fd_pr__pfet_01v8_hvt ad=0.135 pd=1.27 as=0.135 ps=1.27 w=1 l=0.15
X6 a_91_199# C_N VPWR VPB sky130_fd_pr__pfet_01v8_hvt ad=0.1092 pd=1.36 as=0.14575 ps=1.335 w=0.42 l=0.15
X7 a_161_297# a_91_199# Y VPB sky130_fd_pr__pfet_01v8_hvt ad=0.135 pd=1.27 as=0.32 ps=2.64 w=1 l=0.15
.ends

.subckt sky130_fd_sc_hd__o31ai_1 VNB VPB VPWR VGND A1 A2 A3 Y B1 a_109_47#
X0 Y B1 a_109_47# VNB sky130_fd_pr__nfet_01v8 ad=0.221 pd=1.98 as=0.19825 ps=1.26 w=0.65 l=0.15
X1 Y A3 a_193_297# VPB sky130_fd_pr__pfet_01v8_hvt ad=0.3925 pd=1.785 as=0.135 ps=1.27 w=1 l=0.15
X2 a_193_297# A2 a_109_297# VPB sky130_fd_pr__pfet_01v8_hvt ad=0.135 pd=1.27 as=0.135 ps=1.27 w=1 l=0.15
X3 VGND A2 a_109_47# VNB sky130_fd_pr__nfet_01v8 ad=0.08775 pd=0.92 as=0.08775 ps=0.92 w=0.65 l=0.15
X4 VPWR B1 Y VPB sky130_fd_pr__pfet_01v8_hvt ad=0.3 pd=2.6 as=0.3925 ps=1.785 w=1 l=0.15
X5 a_109_47# A3 VGND VNB sky130_fd_pr__nfet_01v8 ad=0.19825 pd=1.26 as=0.08775 ps=0.92 w=0.65 l=0.15
X6 a_109_297# A1 VPWR VPB sky130_fd_pr__pfet_01v8_hvt ad=0.135 pd=1.27 as=0.26 ps=2.52 w=1 l=0.15
X7 a_109_47# A1 VGND VNB sky130_fd_pr__nfet_01v8 ad=0.08775 pd=0.92 as=0.169 ps=1.82 w=0.65 l=0.15
.ends

.subckt sky130_fd_sc_hd__clkbuf_16 VNB VPB VGND VPWR A X a_110_47#
X0 VPWR A a_110_47# VPB sky130_fd_pr__pfet_01v8_hvt ad=0.14 pd=1.28 as=0.14 ps=1.28 w=1 l=0.15
X1 VPWR a_110_47# X VPB sky130_fd_pr__pfet_01v8_hvt ad=0.14 pd=1.28 as=0.14 ps=1.28 w=1 l=0.15
X2 X a_110_47# VPWR VPB sky130_fd_pr__pfet_01v8_hvt ad=0.14 pd=1.28 as=0.14 ps=1.28 w=1 l=0.15
X3 X a_110_47# VPWR VPB sky130_fd_pr__pfet_01v8_hvt ad=0.14 pd=1.28 as=0.14 ps=1.28 w=1 l=0.15
X4 VPWR a_110_47# X VPB sky130_fd_pr__pfet_01v8_hvt ad=0.14 pd=1.28 as=0.14 ps=1.28 w=1 l=0.15
X5 VPWR a_110_47# X VPB sky130_fd_pr__pfet_01v8_hvt ad=0.265 pd=2.53 as=0.14 ps=1.28 w=1 l=0.15
X6 a_110_47# A VPWR VPB sky130_fd_pr__pfet_01v8_hvt ad=0.14 pd=1.28 as=0.265 ps=2.53 w=1 l=0.15
X7 a_110_47# A VGND VNB sky130_fd_pr__nfet_01v8 ad=0.0588 pd=0.7 as=0.0588 ps=0.7 w=0.42 l=0.15
X8 VGND a_110_47# X VNB sky130_fd_pr__nfet_01v8 ad=0.0588 pd=0.7 as=0.0588 ps=0.7 w=0.42 l=0.15
X9 X a_110_47# VGND VNB sky130_fd_pr__nfet_01v8 ad=0.0588 pd=0.7 as=0.0588 ps=0.7 w=0.42 l=0.15
X10 VGND a_110_47# X VNB sky130_fd_pr__nfet_01v8 ad=0.0588 pd=0.7 as=0.0588 ps=0.7 w=0.42 l=0.15
X11 a_110_47# A VPWR VPB sky130_fd_pr__pfet_01v8_hvt ad=0.14 pd=1.28 as=0.14 ps=1.28 w=1 l=0.15
X12 VGND A a_110_47# VNB sky130_fd_pr__nfet_01v8 ad=0.0588 pd=0.7 as=0.0588 ps=0.7 w=0.42 l=0.15
X13 VGND a_110_47# X VNB sky130_fd_pr__nfet_01v8 ad=0.05775 pd=0.695 as=0.0588 ps=0.7 w=0.42 l=0.15
X14 VPWR a_110_47# X VPB sky130_fd_pr__pfet_01v8_hvt ad=0.14 pd=1.28 as=0.14 ps=1.28 w=1 l=0.15
X15 X a_110_47# VPWR VPB sky130_fd_pr__pfet_01v8_hvt ad=0.14 pd=1.28 as=0.14 ps=1.28 w=1 l=0.15
X16 VGND A a_110_47# VNB sky130_fd_pr__nfet_01v8 ad=0.0588 pd=0.7 as=0.0588 ps=0.7 w=0.42 l=0.15
X17 VGND a_110_47# X VNB sky130_fd_pr__nfet_01v8 ad=0.1113 pd=1.37 as=0.0588 ps=0.7 w=0.42 l=0.15
X18 VPWR a_110_47# X VPB sky130_fd_pr__pfet_01v8_hvt ad=0.1375 pd=1.275 as=0.14 ps=1.28 w=1 l=0.15
X19 VGND a_110_47# X VNB sky130_fd_pr__nfet_01v8 ad=0.0588 pd=0.7 as=0.0588 ps=0.7 w=0.42 l=0.15
X20 X a_110_47# VPWR VPB sky130_fd_pr__pfet_01v8_hvt ad=0.14 pd=1.28 as=0.1375 ps=1.275 w=1 l=0.15
X21 a_110_47# A VGND VNB sky130_fd_pr__nfet_01v8 ad=0.0588 pd=0.7 as=0.1113 ps=1.37 w=0.42 l=0.15
X22 VPWR A a_110_47# VPB sky130_fd_pr__pfet_01v8_hvt ad=0.14 pd=1.28 as=0.14 ps=1.28 w=1 l=0.15
X23 VPWR a_110_47# X VPB sky130_fd_pr__pfet_01v8_hvt ad=0.14 pd=1.28 as=0.14 ps=1.28 w=1 l=0.15
X24 VPWR a_110_47# X VPB sky130_fd_pr__pfet_01v8_hvt ad=0.14 pd=1.28 as=0.14 ps=1.28 w=1 l=0.15
X25 VGND a_110_47# X VNB sky130_fd_pr__nfet_01v8 ad=0.0588 pd=0.7 as=0.0588 ps=0.7 w=0.42 l=0.15
X26 X a_110_47# VPWR VPB sky130_fd_pr__pfet_01v8_hvt ad=0.14 pd=1.28 as=0.14 ps=1.28 w=1 l=0.15
X27 VGND a_110_47# X VNB sky130_fd_pr__nfet_01v8 ad=0.0588 pd=0.7 as=0.0588 ps=0.7 w=0.42 l=0.15
X28 VGND a_110_47# X VNB sky130_fd_pr__nfet_01v8 ad=0.0588 pd=0.7 as=0.0588 ps=0.7 w=0.42 l=0.15
X29 X a_110_47# VGND VNB sky130_fd_pr__nfet_01v8 ad=0.0588 pd=0.7 as=0.0588 ps=0.7 w=0.42 l=0.15
X30 X a_110_47# VPWR VPB sky130_fd_pr__pfet_01v8_hvt ad=0.14 pd=1.28 as=0.14 ps=1.28 w=1 l=0.15
X31 X a_110_47# VPWR VPB sky130_fd_pr__pfet_01v8_hvt ad=0.14 pd=1.28 as=0.14 ps=1.28 w=1 l=0.15
X32 X a_110_47# VGND VNB sky130_fd_pr__nfet_01v8 ad=0.0588 pd=0.7 as=0.0588 ps=0.7 w=0.42 l=0.15
X33 VPWR a_110_47# X VPB sky130_fd_pr__pfet_01v8_hvt ad=0.14 pd=1.28 as=0.14 ps=1.28 w=1 l=0.15
X34 X a_110_47# VPWR VPB sky130_fd_pr__pfet_01v8_hvt ad=0.14 pd=1.28 as=0.14 ps=1.28 w=1 l=0.15
X35 X a_110_47# VGND VNB sky130_fd_pr__nfet_01v8 ad=0.0588 pd=0.7 as=0.0588 ps=0.7 w=0.42 l=0.15
X36 X a_110_47# VGND VNB sky130_fd_pr__nfet_01v8 ad=0.0588 pd=0.7 as=0.0588 ps=0.7 w=0.42 l=0.15
X37 X a_110_47# VGND VNB sky130_fd_pr__nfet_01v8 ad=0.0588 pd=0.7 as=0.0588 ps=0.7 w=0.42 l=0.15
X38 X a_110_47# VGND VNB sky130_fd_pr__nfet_01v8 ad=0.0588 pd=0.7 as=0.0588 ps=0.7 w=0.42 l=0.15
X39 X a_110_47# VGND VNB sky130_fd_pr__nfet_01v8 ad=0.0588 pd=0.7 as=0.05775 ps=0.695 w=0.42 l=0.15
.ends

.subckt sky130_fd_sc_hd__nor4_1 VNB VPB VGND VPWR Y D C B A
X0 Y B VGND VNB sky130_fd_pr__nfet_01v8 ad=0.08775 pd=0.92 as=0.08937 ps=0.925 w=0.65 l=0.15
X1 a_191_297# C a_109_297# VPB sky130_fd_pr__pfet_01v8_hvt ad=0.19 pd=1.38 as=0.13 ps=1.26 w=1 l=0.15
X2 VPWR A a_297_297# VPB sky130_fd_pr__pfet_01v8_hvt ad=0.26 pd=2.52 as=0.135 ps=1.27 w=1 l=0.15
X3 VGND C Y VNB sky130_fd_pr__nfet_01v8 ad=0.08937 pd=0.925 as=0.11863 ps=1.015 w=0.65 l=0.15
X4 VGND A Y VNB sky130_fd_pr__nfet_01v8 ad=0.169 pd=1.82 as=0.08775 ps=0.92 w=0.65 l=0.15
X5 a_297_297# B a_191_297# VPB sky130_fd_pr__pfet_01v8_hvt ad=0.135 pd=1.27 as=0.19 ps=1.38 w=1 l=0.15
X6 a_109_297# D Y VPB sky130_fd_pr__pfet_01v8_hvt ad=0.13 pd=1.26 as=0.26 ps=2.52 w=1 l=0.15
X7 Y D VGND VNB sky130_fd_pr__nfet_01v8 ad=0.11863 pd=1.015 as=0.169 ps=1.82 w=0.65 l=0.15
.ends

.subckt sky130_fd_sc_hd__a2bb2oi_1 VNB VPB VGND VPWR Y A2_N A1_N B2 B1 a_109_47# a_397_297#
X0 a_109_47# A2_N a_109_297# VPB sky130_fd_pr__pfet_01v8_hvt ad=0.26 pd=2.52 as=0.105 ps=1.21 w=1 l=0.15
X1 a_397_297# B1 VPWR VPB sky130_fd_pr__pfet_01v8_hvt ad=0.26 pd=2.52 as=0.135 ps=1.27 w=1 l=0.15
X2 VPWR B2 a_397_297# VPB sky130_fd_pr__pfet_01v8_hvt ad=0.135 pd=1.27 as=0.135 ps=1.27 w=1 l=0.15
X3 VGND A2_N a_109_47# VNB sky130_fd_pr__nfet_01v8 ad=0.28275 pd=1.52 as=0.08775 ps=0.92 w=0.65 l=0.15
X4 a_397_297# a_109_47# Y VPB sky130_fd_pr__pfet_01v8_hvt ad=0.135 pd=1.27 as=0.34 ps=2.68 w=1 l=0.15
X5 a_481_47# B2 Y VNB sky130_fd_pr__nfet_01v8 ad=0.08775 pd=0.92 as=0.08775 ps=0.92 w=0.65 l=0.15
X6 Y a_109_47# VGND VNB sky130_fd_pr__nfet_01v8 ad=0.08775 pd=0.92 as=0.28275 ps=1.52 w=0.65 l=0.15
X7 VGND B1 a_481_47# VNB sky130_fd_pr__nfet_01v8 ad=0.169 pd=1.82 as=0.08775 ps=0.92 w=0.65 l=0.15
X8 a_109_297# A1_N VPWR VPB sky130_fd_pr__pfet_01v8_hvt ad=0.105 pd=1.21 as=0.26 ps=2.52 w=1 l=0.15
X9 a_109_47# A1_N VGND VNB sky130_fd_pr__nfet_01v8 ad=0.08775 pd=0.92 as=0.169 ps=1.82 w=0.65 l=0.15
.ends

.subckt sky130_fd_sc_hd__a211oi_1 VNB VPB VPWR VGND Y C1 B1 A1 A2 a_56_297#
X0 a_56_297# A1 VPWR VPB sky130_fd_pr__pfet_01v8_hvt ad=0.14 pd=1.28 as=0.14 ps=1.28 w=1 l=0.15
X1 VPWR A2 a_56_297# VPB sky130_fd_pr__pfet_01v8_hvt ad=0.14 pd=1.28 as=0.265 ps=2.53 w=1 l=0.15
X2 Y C1 VGND VNB sky130_fd_pr__nfet_01v8 ad=0.17225 pd=1.83 as=0.10075 ps=0.96 w=0.65 l=0.15
X3 a_139_47# A2 VGND VNB sky130_fd_pr__nfet_01v8 ad=0.091 pd=0.93 as=0.2665 ps=2.12 w=0.65 l=0.15
X4 a_311_297# B1 a_56_297# VPB sky130_fd_pr__pfet_01v8_hvt ad=0.155 pd=1.31 as=0.14 ps=1.28 w=1 l=0.15
X5 Y C1 a_311_297# VPB sky130_fd_pr__pfet_01v8_hvt ad=0.265 pd=2.53 as=0.155 ps=1.31 w=1 l=0.15
X6 VGND B1 Y VNB sky130_fd_pr__nfet_01v8 ad=0.10075 pd=0.96 as=0.091 ps=0.93 w=0.65 l=0.15
X7 Y A1 a_139_47# VNB sky130_fd_pr__nfet_01v8 ad=0.091 pd=0.93 as=0.091 ps=0.93 w=0.65 l=0.15
.ends

.subckt sky130_fd_sc_hd__or4b_1 VNB VPB VPWR VGND B C A X D_N a_215_297# a_109_53#
X0 X a_215_297# VPWR VPB sky130_fd_pr__pfet_01v8_hvt ad=0.275 pd=2.55 as=0.14825 ps=1.34 w=1 l=0.15
X1 a_109_53# D_N VGND VNB sky130_fd_pr__nfet_01v8 ad=0.1092 pd=1.36 as=0.1092 ps=1.36 w=0.42 l=0.15
X2 a_215_297# a_109_53# VGND VNB sky130_fd_pr__nfet_01v8 ad=0.06405 pd=0.725 as=0.1092 ps=1.36 w=0.42 l=0.15
X3 X a_215_297# VGND VNB sky130_fd_pr__nfet_01v8 ad=0.17875 pd=1.85 as=0.10187 ps=0.99 w=0.65 l=0.15
X4 a_392_297# C a_297_297# VPB sky130_fd_pr__pfet_01v8_hvt ad=0.04515 pd=0.635 as=0.06825 ps=0.745 w=0.42 l=0.15
X5 a_465_297# B a_392_297# VPB sky130_fd_pr__pfet_01v8_hvt ad=0.06405 pd=0.725 as=0.04515 ps=0.635 w=0.42 l=0.15
X6 a_215_297# B VGND VNB sky130_fd_pr__nfet_01v8 ad=0.0567 pd=0.69 as=0.0567 ps=0.69 w=0.42 l=0.15
X7 VPWR A a_465_297# VPB sky130_fd_pr__pfet_01v8_hvt ad=0.14825 pd=1.34 as=0.06405 ps=0.725 w=0.42 l=0.15
X8 a_297_297# a_109_53# a_215_297# VPB sky130_fd_pr__pfet_01v8_hvt ad=0.06825 pd=0.745 as=0.1092 ps=1.36 w=0.42 l=0.15
X9 a_109_53# D_N VPWR VPB sky130_fd_pr__pfet_01v8_hvt ad=0.1092 pd=1.36 as=0.1092 ps=1.36 w=0.42 l=0.15
X10 VGND C a_215_297# VNB sky130_fd_pr__nfet_01v8 ad=0.0567 pd=0.69 as=0.06405 ps=0.725 w=0.42 l=0.15
X11 VGND A a_215_297# VNB sky130_fd_pr__nfet_01v8 ad=0.10187 pd=0.99 as=0.0567 ps=0.69 w=0.42 l=0.15
.ends

.subckt sky130_fd_sc_hd__nand2b_1 VNB VPB VGND VPWR A_N B Y a_27_93#
X0 VGND A_N a_27_93# VNB sky130_fd_pr__nfet_01v8 ad=0.10025 pd=0.985 as=0.1092 ps=1.36 w=0.42 l=0.15
X1 Y a_27_93# a_206_47# VNB sky130_fd_pr__nfet_01v8 ad=0.169 pd=1.82 as=0.08775 ps=0.92 w=0.65 l=0.15
X2 a_206_47# B VGND VNB sky130_fd_pr__nfet_01v8 ad=0.08775 pd=0.92 as=0.10025 ps=0.985 w=0.65 l=0.15
X3 VPWR a_27_93# Y VPB sky130_fd_pr__pfet_01v8_hvt ad=0.265 pd=2.53 as=0.135 ps=1.27 w=1 l=0.15
X4 Y B VPWR VPB sky130_fd_pr__pfet_01v8_hvt ad=0.135 pd=1.27 as=0.14575 ps=1.335 w=1 l=0.15
X5 VPWR A_N a_27_93# VPB sky130_fd_pr__pfet_01v8_hvt ad=0.14575 pd=1.335 as=0.1092 ps=1.36 w=0.42 l=0.15
.ends

.subckt sky130_fd_sc_hd__o41ai_1 VNB VPB VGND VPWR A1 A2 A3 A4 Y B1 a_109_47#
X0 a_348_297# A3 a_193_297# VPB sky130_fd_pr__pfet_01v8_hvt ad=0.135 pd=1.27 as=0.3125 ps=1.625 w=1 l=0.15
X1 a_109_47# A1 VGND VNB sky130_fd_pr__nfet_01v8 ad=0.182 pd=1.86 as=0.11375 ps=1 w=0.65 l=0.15
X2 a_193_297# A4 Y VPB sky130_fd_pr__pfet_01v8_hvt ad=0.3125 pd=1.625 as=0.135 ps=1.27 w=1 l=0.15
X3 VPWR A1 a_432_297# VPB sky130_fd_pr__pfet_01v8_hvt ad=0.28 pd=2.56 as=0.175 ps=1.35 w=1 l=0.15
X4 VGND A4 a_109_47# VNB sky130_fd_pr__nfet_01v8 ad=0.08775 pd=0.92 as=0.20312 ps=1.275 w=0.65 l=0.15
X5 VGND A2 a_109_47# VNB sky130_fd_pr__nfet_01v8 ad=0.11375 pd=1 as=0.08775 ps=0.92 w=0.65 l=0.15
X6 a_109_47# A3 VGND VNB sky130_fd_pr__nfet_01v8 ad=0.08775 pd=0.92 as=0.08775 ps=0.92 w=0.65 l=0.15
X7 a_432_297# A2 a_348_297# VPB sky130_fd_pr__pfet_01v8_hvt ad=0.175 pd=1.35 as=0.135 ps=1.27 w=1 l=0.15
X8 Y B1 VPWR VPB sky130_fd_pr__pfet_01v8_hvt ad=0.135 pd=1.27 as=0.26 ps=2.52 w=1 l=0.15
X9 a_109_47# B1 Y VNB sky130_fd_pr__nfet_01v8 ad=0.20312 pd=1.275 as=0.169 ps=1.82 w=0.65 l=0.15
.ends

.subckt sky130_fd_sc_hd__o211ai_1 VNB VPB VGND VPWR A1 Y C1 B1 A2 a_27_47#
X0 a_110_297# A1 VPWR VPB sky130_fd_pr__pfet_01v8_hvt ad=0.105 pd=1.21 as=0.265 ps=2.53 w=1 l=0.15
X1 VGND A1 a_27_47# VNB sky130_fd_pr__nfet_01v8 ad=0.12675 pd=1.04 as=0.17225 ps=1.83 w=0.65 l=0.15
X2 Y A2 a_110_297# VPB sky130_fd_pr__pfet_01v8_hvt ad=0.195 pd=1.39 as=0.105 ps=1.21 w=1 l=0.15
X3 VPWR B1 Y VPB sky130_fd_pr__pfet_01v8_hvt ad=0.195 pd=1.39 as=0.195 ps=1.39 w=1 l=0.15
X4 a_27_47# A2 VGND VNB sky130_fd_pr__nfet_01v8 ad=0.12675 pd=1.04 as=0.12675 ps=1.04 w=0.65 l=0.15
X5 a_326_47# B1 a_27_47# VNB sky130_fd_pr__nfet_01v8 ad=0.06825 pd=0.86 as=0.12675 ps=1.04 w=0.65 l=0.15
X6 Y C1 VPWR VPB sky130_fd_pr__pfet_01v8_hvt ad=0.635 pd=3.27 as=0.195 ps=1.39 w=1 l=0.15
X7 Y C1 a_326_47# VNB sky130_fd_pr__nfet_01v8 ad=0.39325 pd=2.51 as=0.06825 ps=0.86 w=0.65 l=0.15
.ends

.subckt sky130_fd_sc_hd__or4_1 VNB VPB VPWR VGND B D C A X a_27_297# a_109_297#
X0 a_27_297# B VGND VNB sky130_fd_pr__nfet_01v8 ad=0.0567 pd=0.69 as=0.0567 ps=0.69 w=0.42 l=0.15
X1 a_27_297# D VGND VNB sky130_fd_pr__nfet_01v8 ad=0.0693 pd=0.75 as=0.1092 ps=1.36 w=0.42 l=0.15
X2 a_277_297# B a_205_297# VPB sky130_fd_pr__pfet_01v8_hvt ad=0.0693 pd=0.75 as=0.0441 ps=0.63 w=0.42 l=0.15
X3 VPWR A a_277_297# VPB sky130_fd_pr__pfet_01v8_hvt ad=0.14825 pd=1.34 as=0.0693 ps=0.75 w=0.42 l=0.15
X4 X a_27_297# VGND VNB sky130_fd_pr__nfet_01v8 ad=0.1755 pd=1.84 as=0.10187 ps=0.99 w=0.65 l=0.15
X5 a_205_297# C a_109_297# VPB sky130_fd_pr__pfet_01v8_hvt ad=0.0441 pd=0.63 as=0.0693 ps=0.75 w=0.42 l=0.15
X6 X a_27_297# VPWR VPB sky130_fd_pr__pfet_01v8_hvt ad=0.27 pd=2.54 as=0.14825 ps=1.34 w=1 l=0.15
X7 VGND C a_27_297# VNB sky130_fd_pr__nfet_01v8 ad=0.0567 pd=0.69 as=0.0693 ps=0.75 w=0.42 l=0.15
X8 a_109_297# D a_27_297# VPB sky130_fd_pr__pfet_01v8_hvt ad=0.0693 pd=0.75 as=0.1092 ps=1.36 w=0.42 l=0.15
X9 VGND A a_27_297# VNB sky130_fd_pr__nfet_01v8 ad=0.10187 pd=0.99 as=0.0567 ps=0.69 w=0.42 l=0.15
.ends

.subckt sky130_fd_sc_hd__a222oi_1 VNB VPB VPWR VGND C2 C1 B1 A2 A1 Y B2 a_109_297#
+ a_311_297#
X0 Y B1 a_393_47# VNB sky130_fd_pr__nfet_01v8 ad=0.1056 pd=0.97 as=0.0672 ps=0.85 w=0.64 l=0.15
X1 VGND A2 a_561_47# VNB sky130_fd_pr__nfet_01v8 ad=0.1664 pd=1.8 as=0.1056 ps=0.97 w=0.64 l=0.15
X2 VGND C2 a_109_47# VNB sky130_fd_pr__nfet_01v8 ad=0.2912 pd=1.55 as=0.0672 ps=0.85 w=0.64 l=0.15
X3 Y C2 a_109_297# VPB sky130_fd_pr__pfet_01v8_hvt ad=0.26 pd=2.52 as=0.135 ps=1.27 w=1 l=0.15
X4 VPWR A1 a_311_297# VPB sky130_fd_pr__pfet_01v8_hvt ad=0.165 pd=1.33 as=0.135 ps=1.27 w=1 l=0.15
X5 a_311_297# A2 VPWR VPB sky130_fd_pr__pfet_01v8_hvt ad=0.26 pd=2.52 as=0.165 ps=1.33 w=1 l=0.15
X6 a_311_297# B1 a_109_297# VPB sky130_fd_pr__pfet_01v8_hvt ad=0.135 pd=1.27 as=0.135 ps=1.27 w=1 l=0.15
X7 a_109_297# B2 a_311_297# VPB sky130_fd_pr__pfet_01v8_hvt ad=0.135 pd=1.27 as=0.26 ps=2.52 w=1 l=0.15
X8 a_109_297# C1 Y VPB sky130_fd_pr__pfet_01v8_hvt ad=0.135 pd=1.27 as=0.26 ps=2.52 w=1 l=0.15
X9 a_393_47# B2 VGND VNB sky130_fd_pr__nfet_01v8 ad=0.0672 pd=0.85 as=0.2912 ps=1.55 w=0.64 l=0.15
X10 a_109_47# C1 Y VNB sky130_fd_pr__nfet_01v8 ad=0.0672 pd=0.85 as=0.1664 ps=1.8 w=0.64 l=0.15
X11 a_561_47# A1 Y VNB sky130_fd_pr__nfet_01v8 ad=0.1056 pd=0.97 as=0.1056 ps=0.97 w=0.64 l=0.15
.ends

.subckt sky130_fd_sc_hd__nor4bb_1 VNB VPB VGND VPWR A Y B D_N C_N a_27_410# a_205_93#
X0 Y B VGND VNB sky130_fd_pr__nfet_01v8 ad=0.08775 pd=0.92 as=0.10725 ps=0.98 w=0.65 l=0.15
X1 VGND a_27_410# Y VNB sky130_fd_pr__nfet_01v8 ad=0.10725 pd=0.98 as=0.08775 ps=0.92 w=0.65 l=0.15
X2 VGND C_N a_27_410# VNB sky130_fd_pr__nfet_01v8 ad=0.0609 pd=0.71 as=0.1092 ps=1.36 w=0.42 l=0.15
X3 VGND A Y VNB sky130_fd_pr__nfet_01v8 ad=0.169 pd=1.82 as=0.08775 ps=0.92 w=0.65 l=0.15
X4 VPWR C_N a_27_410# VPB sky130_fd_pr__pfet_01v8_hvt ad=0.1226 pd=1.32 as=0.1092 ps=1.36 w=0.42 l=0.15
X5 a_205_93# D_N VGND VNB sky130_fd_pr__nfet_01v8 ad=0.1092 pd=1.36 as=0.0609 ps=0.71 w=0.42 l=0.15
X6 VPWR A a_573_297# VPB sky130_fd_pr__pfet_01v8_hvt ad=0.26 pd=2.52 as=0.135 ps=1.27 w=1 l=0.15
X7 a_205_93# D_N VPWR VPB sky130_fd_pr__pfet_01v8_hvt ad=0.1085 pd=1.36 as=0.1226 ps=1.32 w=0.42 l=0.15
X8 a_477_297# a_27_410# a_393_297# VPB sky130_fd_pr__pfet_01v8_hvt ad=0.165 pd=1.33 as=0.135 ps=1.27 w=1 l=0.15
X9 a_573_297# B a_477_297# VPB sky130_fd_pr__pfet_01v8_hvt ad=0.135 pd=1.27 as=0.165 ps=1.33 w=1 l=0.15
X10 a_393_297# a_205_93# Y VPB sky130_fd_pr__pfet_01v8_hvt ad=0.135 pd=1.27 as=0.2559 ps=2.52 w=1 l=0.15
X11 Y a_205_93# VGND VNB sky130_fd_pr__nfet_01v8 ad=0.08775 pd=0.92 as=0.169 ps=1.82 w=0.65 l=0.15
.ends

.subckt sky130_fd_sc_hd__and2_0 VNB VPB VPWR VGND X B A a_40_47#
X0 VPWR B a_40_47# VPB sky130_fd_pr__pfet_01v8_hvt ad=0.1841 pd=1.26 as=0.0609 ps=0.71 w=0.42 l=0.15
X1 X a_40_47# VPWR VPB sky130_fd_pr__pfet_01v8_hvt ad=0.1696 pd=1.81 as=0.1841 ps=1.26 w=0.64 l=0.15
X2 VGND B a_123_47# VNB sky130_fd_pr__nfet_01v8 ad=0.0966 pd=0.88 as=0.0441 ps=0.63 w=0.42 l=0.15
X3 X a_40_47# VGND VNB sky130_fd_pr__nfet_01v8 ad=0.1113 pd=1.37 as=0.0966 ps=0.88 w=0.42 l=0.15
X4 a_123_47# A a_40_47# VNB sky130_fd_pr__nfet_01v8 ad=0.0441 pd=0.63 as=0.1113 ps=1.37 w=0.42 l=0.15
X5 a_40_47# A VPWR VPB sky130_fd_pr__pfet_01v8_hvt ad=0.0609 pd=0.71 as=0.1113 ps=1.37 w=0.42 l=0.15
.ends

.subckt sky130_fd_sc_hd__a32oi_1 VNB VPB VGND VPWR B2 Y B1 A1 A2 A3 a_27_297#
X0 VPWR A3 a_27_297# VPB sky130_fd_pr__pfet_01v8_hvt ad=0.26 pd=2.52 as=0.14 ps=1.28 w=1 l=0.15
X1 VGND A3 a_383_47# VNB sky130_fd_pr__nfet_01v8 ad=0.169 pd=1.82 as=0.10725 ps=0.98 w=0.65 l=0.15
X2 a_309_47# A1 Y VNB sky130_fd_pr__nfet_01v8 ad=0.0715 pd=0.87 as=0.15275 ps=1.12 w=0.65 l=0.15
X3 Y B1 a_109_47# VNB sky130_fd_pr__nfet_01v8 ad=0.15275 pd=1.12 as=0.07475 ps=0.88 w=0.65 l=0.15
X4 a_27_297# B1 Y VPB sky130_fd_pr__pfet_01v8_hvt ad=0.215 pd=1.43 as=0.135 ps=1.27 w=1 l=0.15
X5 a_383_47# A2 a_309_47# VNB sky130_fd_pr__nfet_01v8 ad=0.10725 pd=0.98 as=0.0715 ps=0.87 w=0.65 l=0.15
X6 a_27_297# A2 VPWR VPB sky130_fd_pr__pfet_01v8_hvt ad=0.14 pd=1.28 as=0.135 ps=1.27 w=1 l=0.15
X7 Y B2 a_27_297# VPB sky130_fd_pr__pfet_01v8_hvt ad=0.135 pd=1.27 as=0.26 ps=2.52 w=1 l=0.15
X8 VPWR A1 a_27_297# VPB sky130_fd_pr__pfet_01v8_hvt ad=0.135 pd=1.27 as=0.215 ps=1.43 w=1 l=0.15
X9 a_109_47# B2 VGND VNB sky130_fd_pr__nfet_01v8 ad=0.07475 pd=0.88 as=0.169 ps=1.82 w=0.65 l=0.15
.ends

.subckt sky130_fd_sc_hd__a21bo_1 VNB VPB VGND VPWR X A2 A1 B1_N a_215_297# a_27_413#
+ a_298_297#
X0 a_298_297# a_27_413# a_215_297# VPB sky130_fd_pr__pfet_01v8_hvt ad=0.135 pd=1.27 as=0.265 ps=2.53 w=1 l=0.15
X1 a_215_297# a_27_413# VGND VNB sky130_fd_pr__nfet_01v8 ad=0.08775 pd=0.92 as=0.1359 ps=1.1 w=0.65 l=0.15
X2 a_298_297# A2 VPWR VPB sky130_fd_pr__pfet_01v8_hvt ad=0.265 pd=2.53 as=0.14 ps=1.28 w=1 l=0.15
X3 X a_215_297# VGND VNB sky130_fd_pr__nfet_01v8 ad=0.169 pd=1.82 as=0.25837 ps=1.445 w=0.65 l=0.15
X4 VPWR B1_N a_27_413# VPB sky130_fd_pr__pfet_01v8_hvt ad=0.1092 pd=1.36 as=0.1092 ps=1.36 w=0.42 l=0.15
X5 X a_215_297# VPWR VPB sky130_fd_pr__pfet_01v8_hvt ad=0.26 pd=2.52 as=0.26 ps=2.52 w=1 l=0.15
X6 a_382_47# A1 a_215_297# VNB sky130_fd_pr__nfet_01v8 ad=0.091 pd=0.93 as=0.08775 ps=0.92 w=0.65 l=0.15
X7 VGND B1_N a_27_413# VNB sky130_fd_pr__nfet_01v8 ad=0.1359 pd=1.1 as=0.1113 ps=1.37 w=0.42 l=0.15
X8 VPWR A1 a_298_297# VPB sky130_fd_pr__pfet_01v8_hvt ad=0.14 pd=1.28 as=0.135 ps=1.27 w=1 l=0.15
X9 VGND A2 a_382_47# VNB sky130_fd_pr__nfet_01v8 ad=0.25837 pd=1.445 as=0.091 ps=0.93 w=0.65 l=0.15
.ends

.subckt sky130_fd_sc_hd__a31oi_1 VNB VPB VGND VPWR A3 A2 A1 Y B1 a_181_47# a_109_297#
X0 Y A1 a_181_47# VNB sky130_fd_pr__nfet_01v8 ad=0.10563 pd=0.975 as=0.11863 ps=1.015 w=0.65 l=0.15
X1 a_181_47# A2 a_109_47# VNB sky130_fd_pr__nfet_01v8 ad=0.11863 pd=1.015 as=0.06825 ps=0.86 w=0.65 l=0.15
X2 VGND B1 Y VNB sky130_fd_pr__nfet_01v8 ad=0.1755 pd=1.84 as=0.10563 ps=0.975 w=0.65 l=0.15
X3 VPWR A2 a_109_297# VPB sky130_fd_pr__pfet_01v8_hvt ad=0.1525 pd=1.305 as=0.135 ps=1.27 w=1 l=0.15
X4 Y B1 a_109_297# VPB sky130_fd_pr__pfet_01v8_hvt ad=0.27 pd=2.54 as=0.1625 ps=1.325 w=1 l=0.15
X5 a_109_297# A1 VPWR VPB sky130_fd_pr__pfet_01v8_hvt ad=0.1625 pd=1.325 as=0.1525 ps=1.305 w=1 l=0.15
X6 a_109_297# A3 VPWR VPB sky130_fd_pr__pfet_01v8_hvt ad=0.135 pd=1.27 as=0.26 ps=2.52 w=1 l=0.15
X7 a_109_47# A3 VGND VNB sky130_fd_pr__nfet_01v8 ad=0.06825 pd=0.86 as=0.169 ps=1.82 w=0.65 l=0.15
.ends

.subckt sky130_fd_sc_hd__nor2b_1 VNB VPB VGND VPWR B_N A Y a_74_47#
X0 Y a_74_47# a_265_297# VPB sky130_fd_pr__pfet_01v8_hvt ad=0.26 pd=2.52 as=0.105 ps=1.21 w=1 l=0.15
X1 VPWR B_N a_74_47# VPB sky130_fd_pr__pfet_01v8_hvt ad=0.1573 pd=1.39 as=0.1092 ps=1.36 w=0.42 l=0.15
X2 a_265_297# A VPWR VPB sky130_fd_pr__pfet_01v8_hvt ad=0.105 pd=1.21 as=0.1573 ps=1.39 w=1 l=0.15
X3 Y A VGND VNB sky130_fd_pr__nfet_01v8 ad=0.08775 pd=0.92 as=0.10025 ps=0.985 w=0.65 l=0.15
X4 VGND B_N a_74_47# VNB sky130_fd_pr__nfet_01v8 ad=0.10025 pd=0.985 as=0.1092 ps=1.36 w=0.42 l=0.15
X5 VGND a_74_47# Y VNB sky130_fd_pr__nfet_01v8 ad=0.169 pd=1.82 as=0.08775 ps=0.92 w=0.65 l=0.15
.ends

.subckt sky130_fd_sc_hd__o221ai_1 VNB VPB VGND VPWR A1 A2 Y B2 C1 B1 a_213_123# a_109_47#
X0 a_109_47# B1 a_213_123# VNB sky130_fd_pr__nfet_01v8 ad=0.08775 pd=0.92 as=0.1652 ps=1.82 w=0.65 l=0.15
X1 Y B2 a_295_297# VPB sky130_fd_pr__pfet_01v8_hvt ad=0.225 pd=1.45 as=0.12 ps=1.24 w=1 l=0.15
X2 VPWR A1 a_493_297# VPB sky130_fd_pr__pfet_01v8_hvt ad=0.26 pd=2.52 as=0.105 ps=1.21 w=1 l=0.15
X3 a_213_123# B2 a_109_47# VNB sky130_fd_pr__nfet_01v8 ad=0.117 pd=1.01 as=0.08775 ps=0.92 w=0.65 l=0.15
X4 a_295_297# B1 VPWR VPB sky130_fd_pr__pfet_01v8_hvt ad=0.12 pd=1.24 as=0.38 ps=1.76 w=1 l=0.15
X5 a_493_297# A2 Y VPB sky130_fd_pr__pfet_01v8_hvt ad=0.105 pd=1.21 as=0.225 ps=1.45 w=1 l=0.15
X6 VPWR C1 Y VPB sky130_fd_pr__pfet_01v8_hvt ad=0.38 pd=1.76 as=0.28 ps=2.56 w=1 l=0.15
X7 VGND A2 a_213_123# VNB sky130_fd_pr__nfet_01v8 ad=0.08775 pd=0.92 as=0.117 ps=1.01 w=0.65 l=0.15
X8 a_213_123# A1 VGND VNB sky130_fd_pr__nfet_01v8 ad=0.169 pd=1.82 as=0.08775 ps=0.92 w=0.65 l=0.15
X9 a_109_47# C1 Y VNB sky130_fd_pr__nfet_01v8 ad=0.1654 pd=1.82 as=0.169 ps=1.82 w=0.65 l=0.15
.ends

.subckt sky130_fd_sc_hd__inv_1 VNB VPB VGND VPWR A Y
X0 Y A VGND VNB sky130_fd_pr__nfet_01v8 ad=0.169 pd=1.82 as=0.169 ps=1.82 w=0.65 l=0.15
X1 Y A VPWR VPB sky130_fd_pr__pfet_01v8_hvt ad=0.26 pd=2.52 as=0.26 ps=2.52 w=1 l=0.15
.ends

.subckt sky130_fd_sc_hd__mux2_1 VNB VPB VGND VPWR X A1 S A0 a_505_21# a_76_199#
X0 VPWR a_505_21# a_535_374# VPB sky130_fd_pr__pfet_01v8_hvt ad=0.0693 pd=0.75 as=0.0441 ps=0.63 w=0.42 l=0.15
X1 a_505_21# S VPWR VPB sky130_fd_pr__pfet_01v8_hvt ad=0.1176 pd=1.4 as=0.0693 ps=0.75 w=0.42 l=0.15
X2 a_218_374# S VPWR VPB sky130_fd_pr__pfet_01v8_hvt ad=0.07665 pd=0.785 as=0.15835 ps=1.395 w=0.42 l=0.15
X3 VGND a_505_21# a_439_47# VNB sky130_fd_pr__nfet_01v8 ad=0.1449 pd=1.11 as=0.0693 ps=0.75 w=0.42 l=0.15
X4 a_76_199# A0 a_218_374# VPB sky130_fd_pr__pfet_01v8_hvt ad=0.1932 pd=1.34 as=0.07665 ps=0.785 w=0.42 l=0.15
X5 a_505_21# S VGND VNB sky130_fd_pr__nfet_01v8 ad=0.1092 pd=1.36 as=0.1449 ps=1.11 w=0.42 l=0.15
X6 a_439_47# A0 a_76_199# VNB sky130_fd_pr__nfet_01v8 ad=0.0693 pd=0.75 as=0.09975 ps=0.895 w=0.42 l=0.15
X7 a_535_374# A1 a_76_199# VPB sky130_fd_pr__pfet_01v8_hvt ad=0.0441 pd=0.63 as=0.1932 ps=1.34 w=0.42 l=0.15
X8 a_76_199# A1 a_218_47# VNB sky130_fd_pr__nfet_01v8 ad=0.09975 pd=0.895 as=0.0693 ps=0.75 w=0.42 l=0.15
X9 a_218_47# S VGND VNB sky130_fd_pr__nfet_01v8 ad=0.0693 pd=0.75 as=0.11285 ps=1.045 w=0.42 l=0.15
X10 VPWR a_76_199# X VPB sky130_fd_pr__pfet_01v8_hvt ad=0.15835 pd=1.395 as=0.26 ps=2.52 w=1 l=0.15
X11 VGND a_76_199# X VNB sky130_fd_pr__nfet_01v8 ad=0.11285 pd=1.045 as=0.169 ps=1.82 w=0.65 l=0.15
.ends

.subckt sky130_fd_sc_hd__a41oi_1 VNB VPB VGND VPWR A1 A2 A3 A4 Y B1 a_109_297#
X0 a_236_47# A4 VGND VNB sky130_fd_pr__nfet_01v8 ad=0.11375 pd=1 as=0.16342 ps=1.175 w=0.65 l=0.15
X1 a_428_47# A2 a_336_47# VNB sky130_fd_pr__nfet_01v8 ad=0.13813 pd=1.075 as=0.10075 ps=0.96 w=0.65 l=0.15
X2 a_109_297# A1 VPWR VPB sky130_fd_pr__pfet_01v8_hvt ad=0.37 pd=2.74 as=0.2125 ps=1.425 w=1 l=0.15
X3 Y A1 a_428_47# VNB sky130_fd_pr__nfet_01v8 ad=0.2405 pd=2.04 as=0.13813 ps=1.075 w=0.65 l=0.15
X4 a_336_47# A3 a_236_47# VNB sky130_fd_pr__nfet_01v8 ad=0.10075 pd=0.96 as=0.11375 ps=1 w=0.65 l=0.15
X5 VPWR A4 a_109_297# VPB sky130_fd_pr__pfet_01v8_hvt ad=0.205 pd=1.41 as=0.2125 ps=1.425 w=1 l=0.15
X6 a_109_297# B1 Y VPB sky130_fd_pr__pfet_01v8_hvt ad=0.2125 pd=1.425 as=0.26 ps=2.52 w=1 l=0.15
X7 a_109_297# A3 VPWR VPB sky130_fd_pr__pfet_01v8_hvt ad=0.155 pd=1.31 as=0.205 ps=1.41 w=1 l=0.15
X8 VPWR A2 a_109_297# VPB sky130_fd_pr__pfet_01v8_hvt ad=0.2125 pd=1.425 as=0.155 ps=1.31 w=1 l=0.15
X9 VGND B1 Y VNB sky130_fd_pr__nfet_01v8 ad=0.16342 pd=1.175 as=0.169 ps=1.82 w=0.65 l=0.15
.ends

.subckt sky130_fd_sc_hd__o311ai_0 VNB VPB VGND VPWR C1 A1 A2 Y B1 A3 a_138_47#
X0 VGND A2 a_138_47# VNB sky130_fd_pr__nfet_01v8 ad=0.0567 pd=0.69 as=0.0567 ps=0.69 w=0.42 l=0.15
X1 a_138_369# A1 VPWR VPB sky130_fd_pr__pfet_01v8_hvt ad=0.0864 pd=0.91 as=0.1792 ps=1.84 w=0.64 l=0.15
X2 a_138_47# A1 VGND VNB sky130_fd_pr__nfet_01v8 ad=0.0567 pd=0.69 as=0.1176 ps=1.4 w=0.42 l=0.15
X3 a_138_47# A3 VGND VNB sky130_fd_pr__nfet_01v8 ad=0.1281 pd=1.03 as=0.0567 ps=0.69 w=0.42 l=0.15
X4 Y C1 a_458_47# VNB sky130_fd_pr__nfet_01v8 ad=0.1176 pd=1.4 as=0.0441 ps=0.63 w=0.42 l=0.15
X5 Y C1 VPWR VPB sky130_fd_pr__pfet_01v8_hvt ad=0.1984 pd=1.9 as=0.1184 ps=1.01 w=0.64 l=0.15
X6 Y A3 a_222_369# VPB sky130_fd_pr__pfet_01v8_hvt ad=0.144 pd=1.09 as=0.0864 ps=0.91 w=0.64 l=0.15
X7 a_222_369# A2 a_138_369# VPB sky130_fd_pr__pfet_01v8_hvt ad=0.0864 pd=0.91 as=0.0864 ps=0.91 w=0.64 l=0.15
X8 a_458_47# B1 a_138_47# VNB sky130_fd_pr__nfet_01v8 ad=0.0441 pd=0.63 as=0.1281 ps=1.03 w=0.42 l=0.15
X9 VPWR B1 Y VPB sky130_fd_pr__pfet_01v8_hvt ad=0.1184 pd=1.01 as=0.144 ps=1.09 w=0.64 l=0.15
.ends

.subckt chip_top
Xsky130_fd_sc_hd__decap_6_57 VSUBS VSUBS VSUBS VSUBS sky130_fd_sc_hd__decap_6
Xsky130_fd_sc_hd__decap_6_35 VSUBS VSUBS VSUBS VSUBS sky130_fd_sc_hd__decap_6
Xsky130_fd_sc_hd__decap_6_13 VSUBS VSUBS VSUBS VSUBS sky130_fd_sc_hd__decap_6
Xsky130_fd_sc_hd__decap_6_24 VSUBS VSUBS VSUBS VSUBS sky130_fd_sc_hd__decap_6
Xsky130_fd_sc_hd__decap_6_46 VSUBS VSUBS VSUBS VSUBS sky130_fd_sc_hd__decap_6
Xsky130_fd_sc_hd__decap_6_68 VSUBS VSUBS VSUBS VSUBS sky130_fd_sc_hd__decap_6
Xsky130_fd_sc_hd__decap_6_79 VSUBS VSUBS VSUBS VSUBS sky130_fd_sc_hd__decap_6
Xsky130_fd_sc_hd__o21ai_0_4 VSUBS VSUBS VSUBS VSUBS VSUBS VSUBS VSUBS VSUBS VSUBS
+ sky130_fd_sc_hd__o21ai_0
Xsky130_fd_sc_hd__clkinv_1_7 VSUBS VSUBS VSUBS VSUBS VSUBS VSUBS sky130_fd_sc_hd__clkinv_1
Xsky130_fd_sc_hd__decap_12_1010 VSUBS VSUBS VSUBS VSUBS sky130_fd_sc_hd__decap_12
Xsky130_fd_sc_hd__decap_12_1065 VSUBS VSUBS VSUBS VSUBS sky130_fd_sc_hd__decap_12
Xsky130_fd_sc_hd__decap_12_1032 VSUBS VSUBS VSUBS VSUBS sky130_fd_sc_hd__decap_12
Xsky130_fd_sc_hd__decap_12_1054 VSUBS VSUBS VSUBS VSUBS sky130_fd_sc_hd__decap_12
Xsky130_fd_sc_hd__decap_12_1021 VSUBS VSUBS VSUBS VSUBS sky130_fd_sc_hd__decap_12
Xsky130_fd_sc_hd__decap_12_1087 VSUBS VSUBS VSUBS VSUBS sky130_fd_sc_hd__decap_12
Xsky130_fd_sc_hd__decap_12_1076 VSUBS VSUBS VSUBS VSUBS sky130_fd_sc_hd__decap_12
Xsky130_fd_sc_hd__decap_12_1043 VSUBS VSUBS VSUBS VSUBS sky130_fd_sc_hd__decap_12
Xsky130_fd_sc_hd__decap_12_1098 VSUBS VSUBS VSUBS VSUBS sky130_fd_sc_hd__decap_12
Xsky130_fd_sc_hd__dfxtp_1_86 VSUBS VSUBS VSUBS VSUBS VSUBS VSUBS VSUBS sky130_fd_sc_hd__dfxtp_1_86/a_975_413#
+ VSUBS VSUBS sky130_fd_sc_hd__dfxtp_1_86/a_592_47# VSUBS VSUBS sky130_fd_sc_hd__dfxtp_1_86/a_561_413#
+ VSUBS VSUBS VSUBS sky130_fd_sc_hd__dfxtp_1
Xsky130_fd_sc_hd__dfxtp_1_53 VSUBS VSUBS VSUBS VSUBS VSUBS VSUBS VSUBS sky130_fd_sc_hd__dfxtp_1_53/a_975_413#
+ VSUBS VSUBS sky130_fd_sc_hd__dfxtp_1_53/a_592_47# VSUBS VSUBS sky130_fd_sc_hd__dfxtp_1_53/a_561_413#
+ VSUBS VSUBS VSUBS sky130_fd_sc_hd__dfxtp_1
Xsky130_fd_sc_hd__dfxtp_1_75 VSUBS VSUBS VSUBS VSUBS VSUBS VSUBS VSUBS sky130_fd_sc_hd__dfxtp_1_75/a_975_413#
+ VSUBS VSUBS sky130_fd_sc_hd__dfxtp_1_75/a_592_47# VSUBS VSUBS sky130_fd_sc_hd__dfxtp_1_75/a_561_413#
+ VSUBS VSUBS VSUBS sky130_fd_sc_hd__dfxtp_1
Xsky130_fd_sc_hd__dfxtp_1_97 VSUBS VSUBS VSUBS VSUBS sky130_fd_sc_hd__dfxtp_1_97/CLK
+ VSUBS VSUBS sky130_fd_sc_hd__dfxtp_1_97/a_975_413# VSUBS VSUBS sky130_fd_sc_hd__dfxtp_1_97/a_592_47#
+ VSUBS VSUBS sky130_fd_sc_hd__dfxtp_1_97/a_561_413# VSUBS VSUBS VSUBS sky130_fd_sc_hd__dfxtp_1
Xsky130_fd_sc_hd__dfxtp_1_64 VSUBS VSUBS VSUBS VSUBS VSUBS VSUBS sky130_fd_sc_hd__dfxtp_1_64/Q
+ sky130_fd_sc_hd__dfxtp_1_64/a_975_413# VSUBS VSUBS sky130_fd_sc_hd__dfxtp_1_64/a_592_47#
+ VSUBS VSUBS sky130_fd_sc_hd__dfxtp_1_64/a_561_413# VSUBS VSUBS VSUBS sky130_fd_sc_hd__dfxtp_1
Xsky130_fd_sc_hd__dfxtp_1_42 VSUBS VSUBS VSUBS VSUBS VSUBS VSUBS VSUBS sky130_fd_sc_hd__dfxtp_1_42/a_975_413#
+ VSUBS VSUBS sky130_fd_sc_hd__dfxtp_1_42/a_592_47# VSUBS VSUBS sky130_fd_sc_hd__dfxtp_1_42/a_561_413#
+ VSUBS VSUBS VSUBS sky130_fd_sc_hd__dfxtp_1
Xsky130_fd_sc_hd__dfxtp_1_20 VSUBS VSUBS VSUBS VSUBS VSUBS VSUBS VSUBS sky130_fd_sc_hd__dfxtp_1_20/a_975_413#
+ VSUBS VSUBS sky130_fd_sc_hd__dfxtp_1_20/a_592_47# VSUBS VSUBS sky130_fd_sc_hd__dfxtp_1_20/a_561_413#
+ VSUBS VSUBS VSUBS sky130_fd_sc_hd__dfxtp_1
Xsky130_fd_sc_hd__dfxtp_1_31 VSUBS VSUBS VSUBS VSUBS VSUBS VSUBS VSUBS sky130_fd_sc_hd__dfxtp_1_31/a_975_413#
+ VSUBS VSUBS sky130_fd_sc_hd__dfxtp_1_31/a_592_47# VSUBS VSUBS sky130_fd_sc_hd__dfxtp_1_31/a_561_413#
+ VSUBS VSUBS VSUBS sky130_fd_sc_hd__dfxtp_1
Xsky130_fd_sc_hd__mux2i_1_8 VSUBS VSUBS VSUBS VSUBS VSUBS VSUBS VSUBS VSUBS VSUBS
+ VSUBS VSUBS VSUBS sky130_fd_sc_hd__mux2i_1
Xsky130_fd_sc_hd__decap_3_58 VSUBS VSUBS VSUBS VSUBS sky130_fd_sc_hd__decap_3
Xsky130_fd_sc_hd__decap_3_14 VSUBS VSUBS VSUBS VSUBS sky130_fd_sc_hd__decap_3
Xsky130_fd_sc_hd__decap_3_25 VSUBS VSUBS VSUBS VSUBS sky130_fd_sc_hd__decap_3
Xsky130_fd_sc_hd__decap_3_69 VSUBS VSUBS VSUBS VSUBS sky130_fd_sc_hd__decap_3
Xsky130_fd_sc_hd__decap_3_47 VSUBS VSUBS VSUBS VSUBS sky130_fd_sc_hd__decap_3
Xsky130_fd_sc_hd__decap_3_36 VSUBS VSUBS VSUBS VSUBS sky130_fd_sc_hd__decap_3
Xsky130_fd_sc_hd__dfxtp_1_4 VSUBS VSUBS VSUBS VSUBS VSUBS VSUBS sky130_fd_sc_hd__dfxtp_1_4/Q
+ sky130_fd_sc_hd__dfxtp_1_4/a_975_413# VSUBS VSUBS sky130_fd_sc_hd__dfxtp_1_4/a_592_47#
+ VSUBS VSUBS sky130_fd_sc_hd__dfxtp_1_4/a_561_413# VSUBS VSUBS VSUBS sky130_fd_sc_hd__dfxtp_1
Xsky130_fd_sc_hd__mux2i_1_10 VSUBS VSUBS VSUBS VSUBS VSUBS VSUBS VSUBS VSUBS VSUBS
+ VSUBS VSUBS VSUBS sky130_fd_sc_hd__mux2i_1
Xsky130_fd_sc_hd__edfxtp_1_7 VSUBS VSUBS VSUBS VSUBS VSUBS VSUBS VSUBS VSUBS sky130_fd_sc_hd__edfxtp_1_7/a_1717_47#
+ VSUBS VSUBS VSUBS sky130_fd_sc_hd__edfxtp_1_7/a_729_47# VSUBS VSUBS VSUBS VSUBS
+ sky130_fd_sc_hd__edfxtp_1_7/a_729_369# VSUBS sky130_fd_sc_hd__edfxtp_1_7/a_1675_413#
+ VSUBS VSUBS sky130_fd_sc_hd__edfxtp_1
Xsky130_fd_sc_hd__o21ai_0_48 VSUBS VSUBS VSUBS VSUBS VSUBS sky130_fd_sc_hd__o21ai_0_48/A1
+ VSUBS VSUBS VSUBS sky130_fd_sc_hd__o21ai_0
Xsky130_fd_sc_hd__o21ai_0_37 VSUBS VSUBS VSUBS VSUBS VSUBS VSUBS VSUBS VSUBS VSUBS
+ sky130_fd_sc_hd__o21ai_0
Xsky130_fd_sc_hd__o21ai_0_26 VSUBS VSUBS VSUBS VSUBS VSUBS VSUBS VSUBS VSUBS VSUBS
+ sky130_fd_sc_hd__o21ai_0
Xsky130_fd_sc_hd__o21ai_0_15 VSUBS VSUBS VSUBS VSUBS VSUBS VSUBS VSUBS VSUBS VSUBS
+ sky130_fd_sc_hd__o21ai_0
Xsky130_fd_sc_hd__o21ai_0_59 VSUBS VSUBS VSUBS VSUBS VSUBS VSUBS VSUBS VSUBS VSUBS
+ sky130_fd_sc_hd__o21ai_0
Xsky130_fd_sc_hd__nand2_1_9 VSUBS VSUBS VSUBS VSUBS sky130_fd_sc_hd__nand2_1_9/A VSUBS
+ VSUBS sky130_fd_sc_hd__nand2_1
Xsky130_fd_sc_hd__decap_4_90 VSUBS VSUBS VSUBS VSUBS sky130_fd_sc_hd__decap_4
Xsky130_fd_sc_hd__decap_8_170 VSUBS VSUBS VSUBS VSUBS sky130_fd_sc_hd__decap_8
Xsky130_fd_sc_hd__decap_8_192 VSUBS VSUBS VSUBS VSUBS sky130_fd_sc_hd__decap_8
Xsky130_fd_sc_hd__decap_8_181 VSUBS VSUBS VSUBS VSUBS sky130_fd_sc_hd__decap_8
Xsky130_fd_sc_hd__a21oi_1_47 VSUBS VSUBS VSUBS VSUBS VSUBS VSUBS VSUBS VSUBS VSUBS
+ sky130_fd_sc_hd__a21oi_1
Xsky130_fd_sc_hd__a21oi_1_25 VSUBS VSUBS VSUBS VSUBS VSUBS VSUBS VSUBS VSUBS VSUBS
+ sky130_fd_sc_hd__a21oi_1
Xsky130_fd_sc_hd__a21oi_1_36 VSUBS VSUBS VSUBS VSUBS VSUBS VSUBS VSUBS VSUBS VSUBS
+ sky130_fd_sc_hd__a21oi_1
Xsky130_fd_sc_hd__or3_1_0 VSUBS VSUBS VSUBS VSUBS VSUBS VSUBS VSUBS VSUBS VSUBS sky130_fd_sc_hd__or3_1
Xsky130_fd_sc_hd__a21oi_1_14 VSUBS VSUBS VSUBS VSUBS VSUBS VSUBS VSUBS VSUBS VSUBS
+ sky130_fd_sc_hd__a21oi_1
Xsky130_fd_sc_hd__lpflow_inputiso1p_1_2 VSUBS VSUBS VSUBS VSUBS VSUBS VSUBS VSUBS
+ VSUBS sky130_fd_sc_hd__lpflow_inputiso1p_1
Xsky130_fd_sc_hd__decap_6_107 VSUBS VSUBS VSUBS VSUBS sky130_fd_sc_hd__decap_6
Xsky130_fd_sc_hd__decap_6_118 VSUBS VSUBS VSUBS VSUBS sky130_fd_sc_hd__decap_6
Xsky130_fd_sc_hd__decap_12_10 VSUBS VSUBS VSUBS VSUBS sky130_fd_sc_hd__decap_12
Xsky130_fd_sc_hd__decap_12_21 VSUBS VSUBS VSUBS VSUBS sky130_fd_sc_hd__decap_12
Xsky130_fd_sc_hd__decap_12_43 VSUBS VSUBS VSUBS VSUBS sky130_fd_sc_hd__decap_12
Xsky130_fd_sc_hd__decap_12_32 VSUBS VSUBS VSUBS VSUBS sky130_fd_sc_hd__decap_12
Xsky130_fd_sc_hd__nor3_1_6 VSUBS VSUBS VSUBS VSUBS VSUBS VSUBS VSUBS VSUBS sky130_fd_sc_hd__nor3_1
Xsky130_fd_sc_hd__decap_12_54 VSUBS VSUBS VSUBS VSUBS sky130_fd_sc_hd__decap_12
Xsky130_fd_sc_hd__decap_12_65 VSUBS VSUBS VSUBS VSUBS sky130_fd_sc_hd__decap_12
Xsky130_fd_sc_hd__decap_12_76 VSUBS VSUBS VSUBS VSUBS sky130_fd_sc_hd__decap_12
Xsky130_fd_sc_hd__decap_12_98 VSUBS VSUBS VSUBS VSUBS sky130_fd_sc_hd__decap_12
Xsky130_fd_sc_hd__decap_12_87 VSUBS VSUBS VSUBS VSUBS sky130_fd_sc_hd__decap_12
Xsky130_fd_sc_hd__decap_12_407 VSUBS VSUBS VSUBS VSUBS sky130_fd_sc_hd__decap_12
Xsky130_fd_sc_hd__decap_12_418 VSUBS VSUBS VSUBS VSUBS sky130_fd_sc_hd__decap_12
Xsky130_fd_sc_hd__decap_12_429 VSUBS VSUBS VSUBS VSUBS sky130_fd_sc_hd__decap_12
Xsky130_fd_sc_hd__decap_12_930 VSUBS VSUBS VSUBS VSUBS sky130_fd_sc_hd__decap_12
Xsky130_fd_sc_hd__decap_12_963 VSUBS VSUBS VSUBS VSUBS sky130_fd_sc_hd__decap_12
Xsky130_fd_sc_hd__decap_12_952 VSUBS VSUBS VSUBS VSUBS sky130_fd_sc_hd__decap_12
Xsky130_fd_sc_hd__decap_12_941 VSUBS VSUBS VSUBS VSUBS sky130_fd_sc_hd__decap_12
Xsky130_fd_sc_hd__decap_12_985 VSUBS VSUBS VSUBS VSUBS sky130_fd_sc_hd__decap_12
Xsky130_fd_sc_hd__decap_12_996 VSUBS VSUBS VSUBS VSUBS sky130_fd_sc_hd__decap_12
Xsky130_fd_sc_hd__decap_12_974 VSUBS VSUBS VSUBS VSUBS sky130_fd_sc_hd__decap_12
Xsky130_fd_sc_hd__decap_12_226 VSUBS VSUBS VSUBS VSUBS sky130_fd_sc_hd__decap_12
Xsky130_fd_sc_hd__decap_12_237 VSUBS VSUBS VSUBS VSUBS sky130_fd_sc_hd__decap_12
Xsky130_fd_sc_hd__decap_12_215 VSUBS VSUBS VSUBS VSUBS sky130_fd_sc_hd__decap_12
Xsky130_fd_sc_hd__decap_12_248 VSUBS VSUBS VSUBS VSUBS sky130_fd_sc_hd__decap_12
Xsky130_fd_sc_hd__decap_12_204 VSUBS VSUBS VSUBS VSUBS sky130_fd_sc_hd__decap_12
Xsky130_fd_sc_hd__decap_12_259 VSUBS VSUBS VSUBS VSUBS sky130_fd_sc_hd__decap_12
Xsky130_fd_sc_hd__xor2_1_3 VSUBS VSUBS VSUBS VSUBS VSUBS VSUBS VSUBS VSUBS VSUBS sky130_fd_sc_hd__xor2_1
Xsky130_fd_sc_hd__and3_1_5 VSUBS VSUBS VSUBS VSUBS VSUBS VSUBS VSUBS VSUBS VSUBS sky130_fd_sc_hd__and3_1
Xsky130_fd_sc_hd__decap_12_782 VSUBS VSUBS VSUBS VSUBS sky130_fd_sc_hd__decap_12
Xsky130_fd_sc_hd__decap_12_771 VSUBS VSUBS VSUBS VSUBS sky130_fd_sc_hd__decap_12
Xsky130_fd_sc_hd__decap_12_760 VSUBS VSUBS VSUBS VSUBS sky130_fd_sc_hd__decap_12
Xsky130_fd_sc_hd__decap_12_793 VSUBS VSUBS VSUBS VSUBS sky130_fd_sc_hd__decap_12
Xsky130_fd_sc_hd__decap_6_69 VSUBS VSUBS VSUBS VSUBS sky130_fd_sc_hd__decap_6
Xsky130_fd_sc_hd__decap_6_58 VSUBS VSUBS VSUBS VSUBS sky130_fd_sc_hd__decap_6
Xsky130_fd_sc_hd__decap_6_36 VSUBS VSUBS VSUBS VSUBS sky130_fd_sc_hd__decap_6
Xsky130_fd_sc_hd__decap_6_14 VSUBS VSUBS VSUBS VSUBS sky130_fd_sc_hd__decap_6
Xsky130_fd_sc_hd__decap_6_25 VSUBS VSUBS VSUBS VSUBS sky130_fd_sc_hd__decap_6
Xsky130_fd_sc_hd__decap_6_47 VSUBS VSUBS VSUBS VSUBS sky130_fd_sc_hd__decap_6
Xsky130_fd_sc_hd__o21ai_0_5 VSUBS VSUBS VSUBS VSUBS sky130_fd_sc_hd__o21ai_0_5/B1
+ VSUBS VSUBS VSUBS VSUBS sky130_fd_sc_hd__o21ai_0
Xsky130_fd_sc_hd__clkinv_1_8 VSUBS VSUBS VSUBS VSUBS VSUBS VSUBS sky130_fd_sc_hd__clkinv_1
Xsky130_fd_sc_hd__decap_12_1011 VSUBS VSUBS VSUBS VSUBS sky130_fd_sc_hd__decap_12
Xsky130_fd_sc_hd__decap_12_1022 VSUBS VSUBS VSUBS VSUBS sky130_fd_sc_hd__decap_12
Xsky130_fd_sc_hd__decap_12_1000 VSUBS VSUBS VSUBS VSUBS sky130_fd_sc_hd__decap_12
Xsky130_fd_sc_hd__decap_12_1033 VSUBS VSUBS VSUBS VSUBS sky130_fd_sc_hd__decap_12
Xsky130_fd_sc_hd__decap_12_1044 VSUBS VSUBS VSUBS VSUBS sky130_fd_sc_hd__decap_12
Xsky130_fd_sc_hd__decap_12_1066 VSUBS VSUBS VSUBS VSUBS sky130_fd_sc_hd__decap_12
Xsky130_fd_sc_hd__decap_12_1055 VSUBS VSUBS VSUBS VSUBS sky130_fd_sc_hd__decap_12
Xsky130_fd_sc_hd__decap_12_1099 VSUBS VSUBS VSUBS VSUBS sky130_fd_sc_hd__decap_12
Xsky130_fd_sc_hd__decap_12_1088 VSUBS VSUBS VSUBS VSUBS sky130_fd_sc_hd__decap_12
Xsky130_fd_sc_hd__decap_12_1077 VSUBS VSUBS VSUBS VSUBS sky130_fd_sc_hd__decap_12
Xsky130_fd_sc_hd__decap_12_590 VSUBS VSUBS VSUBS VSUBS sky130_fd_sc_hd__decap_12
Xsky130_fd_sc_hd__dfxtp_1_76 VSUBS VSUBS VSUBS VSUBS VSUBS VSUBS VSUBS sky130_fd_sc_hd__dfxtp_1_76/a_975_413#
+ VSUBS VSUBS sky130_fd_sc_hd__dfxtp_1_76/a_592_47# VSUBS VSUBS sky130_fd_sc_hd__dfxtp_1_76/a_561_413#
+ VSUBS VSUBS VSUBS sky130_fd_sc_hd__dfxtp_1
Xsky130_fd_sc_hd__dfxtp_1_54 VSUBS VSUBS VSUBS VSUBS VSUBS VSUBS VSUBS sky130_fd_sc_hd__dfxtp_1_54/a_975_413#
+ VSUBS VSUBS sky130_fd_sc_hd__dfxtp_1_54/a_592_47# VSUBS VSUBS sky130_fd_sc_hd__dfxtp_1_54/a_561_413#
+ VSUBS VSUBS VSUBS sky130_fd_sc_hd__dfxtp_1
Xsky130_fd_sc_hd__dfxtp_1_65 VSUBS VSUBS VSUBS VSUBS sky130_fd_sc_hd__dfxtp_1_66/CLK
+ sky130_fd_sc_hd__dfxtp_1_66/D VSUBS sky130_fd_sc_hd__dfxtp_1_65/a_975_413# VSUBS
+ VSUBS sky130_fd_sc_hd__dfxtp_1_65/a_592_47# VSUBS VSUBS sky130_fd_sc_hd__dfxtp_1_65/a_561_413#
+ VSUBS sky130_fd_sc_hd__dfxtp_1_66/a_381_47# VSUBS sky130_fd_sc_hd__dfxtp_1
Xsky130_fd_sc_hd__dfxtp_1_87 VSUBS VSUBS VSUBS VSUBS VSUBS VSUBS VSUBS sky130_fd_sc_hd__dfxtp_1_87/a_975_413#
+ VSUBS VSUBS VSUBS VSUBS VSUBS VSUBS VSUBS VSUBS VSUBS sky130_fd_sc_hd__dfxtp_1
Xsky130_fd_sc_hd__dfxtp_1_98 VSUBS VSUBS VSUBS VSUBS VSUBS VSUBS VSUBS sky130_fd_sc_hd__dfxtp_1_98/a_975_413#
+ VSUBS VSUBS sky130_fd_sc_hd__dfxtp_1_98/a_592_47# VSUBS VSUBS sky130_fd_sc_hd__dfxtp_1_98/a_561_413#
+ VSUBS VSUBS VSUBS sky130_fd_sc_hd__dfxtp_1
Xsky130_fd_sc_hd__dfxtp_1_10 VSUBS VSUBS VSUBS VSUBS VSUBS VSUBS VSUBS sky130_fd_sc_hd__dfxtp_1_10/a_975_413#
+ VSUBS VSUBS sky130_fd_sc_hd__dfxtp_1_10/a_592_47# VSUBS VSUBS sky130_fd_sc_hd__dfxtp_1_10/a_561_413#
+ VSUBS VSUBS VSUBS sky130_fd_sc_hd__dfxtp_1
Xsky130_fd_sc_hd__dfxtp_1_32 VSUBS VSUBS VSUBS VSUBS sky130_fd_sc_hd__dfxtp_1_33/CLK
+ sky130_fd_sc_hd__dfxtp_1_33/D VSUBS sky130_fd_sc_hd__dfxtp_1_32/a_975_413# VSUBS
+ VSUBS sky130_fd_sc_hd__dfxtp_1_32/a_592_47# VSUBS VSUBS sky130_fd_sc_hd__dfxtp_1_32/a_561_413#
+ VSUBS sky130_fd_sc_hd__dfxtp_1_33/a_381_47# VSUBS sky130_fd_sc_hd__dfxtp_1
Xsky130_fd_sc_hd__dfxtp_1_43 VSUBS VSUBS VSUBS VSUBS VSUBS VSUBS VSUBS sky130_fd_sc_hd__dfxtp_1_43/a_975_413#
+ VSUBS VSUBS sky130_fd_sc_hd__dfxtp_1_43/a_592_47# VSUBS VSUBS sky130_fd_sc_hd__dfxtp_1_43/a_561_413#
+ VSUBS VSUBS VSUBS sky130_fd_sc_hd__dfxtp_1
Xsky130_fd_sc_hd__dfxtp_1_21 VSUBS VSUBS VSUBS VSUBS sky130_fd_sc_hd__dfxtp_1_21/CLK
+ VSUBS VSUBS sky130_fd_sc_hd__dfxtp_1_21/a_975_413# VSUBS VSUBS sky130_fd_sc_hd__dfxtp_1_21/a_592_47#
+ VSUBS VSUBS sky130_fd_sc_hd__dfxtp_1_21/a_561_413# VSUBS VSUBS VSUBS sky130_fd_sc_hd__dfxtp_1
Xsky130_fd_sc_hd__mux2i_1_9 VSUBS VSUBS VSUBS VSUBS VSUBS VSUBS VSUBS VSUBS VSUBS
+ VSUBS VSUBS VSUBS sky130_fd_sc_hd__mux2i_1
Xsky130_fd_sc_hd__decap_3_15 VSUBS VSUBS VSUBS VSUBS sky130_fd_sc_hd__decap_3
Xsky130_fd_sc_hd__decap_3_59 VSUBS VSUBS VSUBS VSUBS sky130_fd_sc_hd__decap_3
Xsky130_fd_sc_hd__decap_3_26 VSUBS VSUBS VSUBS VSUBS sky130_fd_sc_hd__decap_3
Xsky130_fd_sc_hd__decap_3_37 VSUBS VSUBS VSUBS VSUBS sky130_fd_sc_hd__decap_3
Xsky130_fd_sc_hd__decap_3_48 VSUBS VSUBS VSUBS VSUBS sky130_fd_sc_hd__decap_3
Xsky130_fd_sc_hd__dfxtp_1_5 VSUBS VSUBS VSUBS VSUBS sky130_fd_sc_hd__dfxtp_1_5/CLK
+ VSUBS VSUBS sky130_fd_sc_hd__dfxtp_1_5/a_975_413# VSUBS VSUBS sky130_fd_sc_hd__dfxtp_1_5/a_592_47#
+ VSUBS VSUBS sky130_fd_sc_hd__dfxtp_1_5/a_561_413# VSUBS VSUBS VSUBS sky130_fd_sc_hd__dfxtp_1
Xsky130_fd_sc_hd__mux2i_1_11 VSUBS VSUBS VSUBS VSUBS VSUBS VSUBS VSUBS VSUBS VSUBS
+ VSUBS VSUBS VSUBS sky130_fd_sc_hd__mux2i_1
Xsky130_fd_sc_hd__o21ai_0_49 VSUBS VSUBS VSUBS VSUBS VSUBS VSUBS VSUBS VSUBS VSUBS
+ sky130_fd_sc_hd__o21ai_0
Xsky130_fd_sc_hd__o21ai_0_38 VSUBS VSUBS VSUBS VSUBS VSUBS VSUBS VSUBS VSUBS VSUBS
+ sky130_fd_sc_hd__o21ai_0
Xsky130_fd_sc_hd__o21ai_0_27 VSUBS VSUBS VSUBS VSUBS VSUBS VSUBS VSUBS sky130_fd_sc_hd__o21ai_0_27/A2
+ VSUBS sky130_fd_sc_hd__o21ai_0
Xsky130_fd_sc_hd__o21ai_0_16 VSUBS VSUBS VSUBS VSUBS VSUBS VSUBS VSUBS VSUBS VSUBS
+ sky130_fd_sc_hd__o21ai_0
Xsky130_fd_sc_hd__decap_4_91 VSUBS VSUBS VSUBS VSUBS sky130_fd_sc_hd__decap_4
Xsky130_fd_sc_hd__decap_4_80 VSUBS VSUBS VSUBS VSUBS sky130_fd_sc_hd__decap_4
Xsky130_fd_sc_hd__decap_8_160 VSUBS VSUBS VSUBS VSUBS sky130_fd_sc_hd__decap_8
Xsky130_fd_sc_hd__decap_8_171 VSUBS VSUBS VSUBS VSUBS sky130_fd_sc_hd__decap_8
Xsky130_fd_sc_hd__decap_8_193 VSUBS VSUBS VSUBS VSUBS sky130_fd_sc_hd__decap_8
Xsky130_fd_sc_hd__decap_8_182 VSUBS VSUBS VSUBS VSUBS sky130_fd_sc_hd__decap_8
Xsky130_fd_sc_hd__a21oi_1_26 VSUBS VSUBS VSUBS VSUBS VSUBS VSUBS VSUBS VSUBS VSUBS
+ sky130_fd_sc_hd__a21oi_1
Xsky130_fd_sc_hd__a21oi_1_48 VSUBS VSUBS VSUBS VSUBS VSUBS VSUBS VSUBS VSUBS VSUBS
+ sky130_fd_sc_hd__a21oi_1
Xsky130_fd_sc_hd__a21oi_1_37 VSUBS VSUBS VSUBS VSUBS VSUBS VSUBS VSUBS VSUBS VSUBS
+ sky130_fd_sc_hd__a21oi_1
Xsky130_fd_sc_hd__a21oi_1_15 VSUBS VSUBS VSUBS VSUBS VSUBS VSUBS VSUBS VSUBS VSUBS
+ sky130_fd_sc_hd__a21oi_1
Xsky130_fd_sc_hd__decap_6_108 VSUBS VSUBS VSUBS VSUBS sky130_fd_sc_hd__decap_6
Xsky130_fd_sc_hd__nor3_1_7 VSUBS VSUBS VSUBS VSUBS VSUBS VSUBS VSUBS VSUBS sky130_fd_sc_hd__nor3_1
Xsky130_fd_sc_hd__decap_6_119 VSUBS VSUBS VSUBS VSUBS sky130_fd_sc_hd__decap_6
Xsky130_fd_sc_hd__decap_12_11 VSUBS VSUBS VSUBS VSUBS sky130_fd_sc_hd__decap_12
Xsky130_fd_sc_hd__decap_12_55 VSUBS VSUBS VSUBS VSUBS sky130_fd_sc_hd__decap_12
Xsky130_fd_sc_hd__decap_12_66 VSUBS VSUBS VSUBS VSUBS sky130_fd_sc_hd__decap_12
Xsky130_fd_sc_hd__decap_12_44 VSUBS VSUBS VSUBS VSUBS sky130_fd_sc_hd__decap_12
Xsky130_fd_sc_hd__decap_12_77 VSUBS VSUBS VSUBS VSUBS sky130_fd_sc_hd__decap_12
Xsky130_fd_sc_hd__decap_12_33 VSUBS VSUBS VSUBS VSUBS sky130_fd_sc_hd__decap_12
Xsky130_fd_sc_hd__decap_12_22 VSUBS VSUBS VSUBS VSUBS sky130_fd_sc_hd__decap_12
Xsky130_fd_sc_hd__decap_12_88 VSUBS VSUBS VSUBS VSUBS sky130_fd_sc_hd__decap_12
Xsky130_fd_sc_hd__decap_12_99 VSUBS VSUBS VSUBS VSUBS sky130_fd_sc_hd__decap_12
Xsky130_fd_sc_hd__decap_12_408 VSUBS VSUBS VSUBS VSUBS sky130_fd_sc_hd__decap_12
Xsky130_fd_sc_hd__decap_12_419 VSUBS VSUBS VSUBS VSUBS sky130_fd_sc_hd__decap_12
Xsky130_fd_sc_hd__decap_12_997 VSUBS VSUBS VSUBS VSUBS sky130_fd_sc_hd__decap_12
Xsky130_fd_sc_hd__decap_12_986 VSUBS VSUBS VSUBS VSUBS sky130_fd_sc_hd__decap_12
Xsky130_fd_sc_hd__decap_12_953 VSUBS VSUBS VSUBS VSUBS sky130_fd_sc_hd__decap_12
Xsky130_fd_sc_hd__decap_12_920 VSUBS VSUBS VSUBS VSUBS sky130_fd_sc_hd__decap_12
Xsky130_fd_sc_hd__decap_12_964 VSUBS VSUBS VSUBS VSUBS sky130_fd_sc_hd__decap_12
Xsky130_fd_sc_hd__decap_12_931 VSUBS VSUBS VSUBS VSUBS sky130_fd_sc_hd__decap_12
Xsky130_fd_sc_hd__decap_12_975 VSUBS VSUBS VSUBS VSUBS sky130_fd_sc_hd__decap_12
Xsky130_fd_sc_hd__decap_12_942 VSUBS VSUBS VSUBS VSUBS sky130_fd_sc_hd__decap_12
Xsky130_fd_sc_hd__decap_12_216 VSUBS VSUBS VSUBS VSUBS sky130_fd_sc_hd__decap_12
Xsky130_fd_sc_hd__decap_12_227 VSUBS VSUBS VSUBS VSUBS sky130_fd_sc_hd__decap_12
Xsky130_fd_sc_hd__decap_12_238 VSUBS VSUBS VSUBS VSUBS sky130_fd_sc_hd__decap_12
Xsky130_fd_sc_hd__decap_12_249 VSUBS VSUBS VSUBS VSUBS sky130_fd_sc_hd__decap_12
Xsky130_fd_sc_hd__decap_12_205 VSUBS VSUBS VSUBS VSUBS sky130_fd_sc_hd__decap_12
Xsky130_fd_sc_hd__xor2_1_4 VSUBS VSUBS VSUBS VSUBS VSUBS VSUBS VSUBS VSUBS VSUBS sky130_fd_sc_hd__xor2_1
Xsky130_fd_sc_hd__and3_1_6 VSUBS VSUBS VSUBS VSUBS VSUBS VSUBS VSUBS VSUBS VSUBS sky130_fd_sc_hd__and3_1
Xsky130_fd_sc_hd__decap_12_783 VSUBS VSUBS VSUBS VSUBS sky130_fd_sc_hd__decap_12
Xsky130_fd_sc_hd__decap_12_750 VSUBS VSUBS VSUBS VSUBS sky130_fd_sc_hd__decap_12
Xsky130_fd_sc_hd__decap_12_772 VSUBS VSUBS VSUBS VSUBS sky130_fd_sc_hd__decap_12
Xsky130_fd_sc_hd__decap_12_761 VSUBS VSUBS VSUBS VSUBS sky130_fd_sc_hd__decap_12
Xsky130_fd_sc_hd__decap_12_794 VSUBS VSUBS VSUBS VSUBS sky130_fd_sc_hd__decap_12
Xsky130_fd_sc_hd__nor3_1_10 VSUBS VSUBS VSUBS VSUBS VSUBS VSUBS VSUBS VSUBS sky130_fd_sc_hd__nor3_1
Xsky130_fd_sc_hd__decap_6_59 VSUBS VSUBS VSUBS VSUBS sky130_fd_sc_hd__decap_6
Xsky130_fd_sc_hd__decap_6_37 VSUBS VSUBS VSUBS VSUBS sky130_fd_sc_hd__decap_6
Xsky130_fd_sc_hd__decap_6_15 VSUBS VSUBS VSUBS VSUBS sky130_fd_sc_hd__decap_6
Xsky130_fd_sc_hd__decap_6_48 VSUBS VSUBS VSUBS VSUBS sky130_fd_sc_hd__decap_6
Xsky130_fd_sc_hd__decap_6_26 VSUBS VSUBS VSUBS VSUBS sky130_fd_sc_hd__decap_6
Xsky130_fd_sc_hd__o21ai_0_6 VSUBS VSUBS VSUBS VSUBS VSUBS VSUBS VSUBS VSUBS VSUBS
+ sky130_fd_sc_hd__o21ai_0
Xsky130_fd_sc_hd__clkinv_1_9 VSUBS VSUBS VSUBS VSUBS VSUBS VSUBS sky130_fd_sc_hd__clkinv_1
Xsky130_fd_sc_hd__decap_12_1067 VSUBS VSUBS VSUBS VSUBS sky130_fd_sc_hd__decap_12
Xsky130_fd_sc_hd__decap_12_1056 VSUBS VSUBS VSUBS VSUBS sky130_fd_sc_hd__decap_12
Xsky130_fd_sc_hd__decap_12_1001 VSUBS VSUBS VSUBS VSUBS sky130_fd_sc_hd__decap_12
Xsky130_fd_sc_hd__decap_12_1012 VSUBS VSUBS VSUBS VSUBS sky130_fd_sc_hd__decap_12
Xsky130_fd_sc_hd__decap_12_1045 VSUBS VSUBS VSUBS VSUBS sky130_fd_sc_hd__decap_12
Xsky130_fd_sc_hd__decap_12_1023 VSUBS VSUBS VSUBS VSUBS sky130_fd_sc_hd__decap_12
Xsky130_fd_sc_hd__decap_12_1034 VSUBS VSUBS VSUBS VSUBS sky130_fd_sc_hd__decap_12
Xsky130_fd_sc_hd__decap_12_1078 VSUBS VSUBS VSUBS VSUBS sky130_fd_sc_hd__decap_12
Xsky130_fd_sc_hd__decap_12_1089 VSUBS VSUBS VSUBS VSUBS sky130_fd_sc_hd__decap_12
Xsky130_fd_sc_hd__decap_12_591 VSUBS VSUBS VSUBS VSUBS sky130_fd_sc_hd__decap_12
Xsky130_fd_sc_hd__decap_12_580 VSUBS VSUBS VSUBS VSUBS sky130_fd_sc_hd__decap_12
Xsky130_fd_sc_hd__dfxtp_1_33 VSUBS VSUBS VSUBS VSUBS sky130_fd_sc_hd__dfxtp_1_33/CLK
+ sky130_fd_sc_hd__dfxtp_1_33/D VSUBS sky130_fd_sc_hd__dfxtp_1_33/a_975_413# VSUBS
+ VSUBS sky130_fd_sc_hd__dfxtp_1_33/a_592_47# VSUBS VSUBS sky130_fd_sc_hd__dfxtp_1_33/a_561_413#
+ VSUBS sky130_fd_sc_hd__dfxtp_1_33/a_381_47# VSUBS sky130_fd_sc_hd__dfxtp_1
Xsky130_fd_sc_hd__dfxtp_1_11 VSUBS VSUBS VSUBS VSUBS VSUBS VSUBS VSUBS sky130_fd_sc_hd__dfxtp_1_11/a_975_413#
+ VSUBS VSUBS sky130_fd_sc_hd__dfxtp_1_11/a_592_47# VSUBS VSUBS sky130_fd_sc_hd__dfxtp_1_11/a_561_413#
+ VSUBS VSUBS VSUBS sky130_fd_sc_hd__dfxtp_1
Xsky130_fd_sc_hd__dfxtp_1_22 VSUBS VSUBS VSUBS VSUBS sky130_fd_sc_hd__a31oi_1_2/A2
+ VSUBS VSUBS sky130_fd_sc_hd__dfxtp_1_22/a_975_413# VSUBS VSUBS sky130_fd_sc_hd__dfxtp_1_22/a_592_47#
+ VSUBS VSUBS sky130_fd_sc_hd__dfxtp_1_22/a_561_413# VSUBS VSUBS VSUBS sky130_fd_sc_hd__dfxtp_1
Xsky130_fd_sc_hd__dfxtp_1_55 VSUBS VSUBS VSUBS VSUBS VSUBS VSUBS VSUBS sky130_fd_sc_hd__dfxtp_1_55/a_975_413#
+ VSUBS VSUBS sky130_fd_sc_hd__dfxtp_1_55/a_592_47# VSUBS VSUBS sky130_fd_sc_hd__dfxtp_1_55/a_561_413#
+ VSUBS VSUBS VSUBS sky130_fd_sc_hd__dfxtp_1
Xsky130_fd_sc_hd__dfxtp_1_77 VSUBS VSUBS VSUBS VSUBS sky130_fd_sc_hd__dfxtp_1_78/CLK
+ sky130_fd_sc_hd__dfxtp_1_78/D VSUBS sky130_fd_sc_hd__dfxtp_1_77/a_975_413# VSUBS
+ VSUBS sky130_fd_sc_hd__dfxtp_1_77/a_592_47# VSUBS VSUBS sky130_fd_sc_hd__dfxtp_1_77/a_561_413#
+ VSUBS sky130_fd_sc_hd__dfxtp_1_78/a_381_47# VSUBS sky130_fd_sc_hd__dfxtp_1
Xsky130_fd_sc_hd__dfxtp_1_88 VSUBS VSUBS VSUBS VSUBS VSUBS VSUBS VSUBS sky130_fd_sc_hd__dfxtp_1_88/a_975_413#
+ VSUBS VSUBS sky130_fd_sc_hd__dfxtp_1_88/a_592_47# VSUBS VSUBS sky130_fd_sc_hd__dfxtp_1_88/a_561_413#
+ VSUBS VSUBS VSUBS sky130_fd_sc_hd__dfxtp_1
Xsky130_fd_sc_hd__dfxtp_1_66 VSUBS VSUBS VSUBS VSUBS sky130_fd_sc_hd__dfxtp_1_66/CLK
+ sky130_fd_sc_hd__dfxtp_1_66/D VSUBS sky130_fd_sc_hd__dfxtp_1_66/a_975_413# VSUBS
+ VSUBS sky130_fd_sc_hd__dfxtp_1_66/a_592_47# VSUBS VSUBS sky130_fd_sc_hd__dfxtp_1_66/a_561_413#
+ VSUBS sky130_fd_sc_hd__dfxtp_1_66/a_381_47# VSUBS sky130_fd_sc_hd__dfxtp_1
Xsky130_fd_sc_hd__dfxtp_1_99 VSUBS VSUBS VSUBS VSUBS VSUBS VSUBS VSUBS sky130_fd_sc_hd__dfxtp_1_99/a_975_413#
+ VSUBS VSUBS sky130_fd_sc_hd__dfxtp_1_99/a_592_47# VSUBS VSUBS sky130_fd_sc_hd__dfxtp_1_99/a_561_413#
+ VSUBS VSUBS VSUBS sky130_fd_sc_hd__dfxtp_1
Xsky130_fd_sc_hd__dfxtp_1_44 VSUBS VSUBS VSUBS VSUBS VSUBS VSUBS VSUBS sky130_fd_sc_hd__dfxtp_1_44/a_975_413#
+ VSUBS VSUBS sky130_fd_sc_hd__dfxtp_1_44/a_592_47# VSUBS VSUBS sky130_fd_sc_hd__dfxtp_1_44/a_561_413#
+ VSUBS VSUBS VSUBS sky130_fd_sc_hd__dfxtp_1
Xsky130_fd_sc_hd__decap_3_16 VSUBS VSUBS VSUBS VSUBS sky130_fd_sc_hd__decap_3
Xsky130_fd_sc_hd__decap_3_27 VSUBS VSUBS VSUBS VSUBS sky130_fd_sc_hd__decap_3
Xsky130_fd_sc_hd__decap_3_49 VSUBS VSUBS VSUBS VSUBS sky130_fd_sc_hd__decap_3
Xsky130_fd_sc_hd__decap_3_38 VSUBS VSUBS VSUBS VSUBS sky130_fd_sc_hd__decap_3
Xsky130_fd_sc_hd__dfxtp_1_6 VSUBS VSUBS VSUBS VSUBS sky130_fd_sc_hd__dfxtp_1_6/CLK
+ VSUBS VSUBS sky130_fd_sc_hd__dfxtp_1_6/a_975_413# VSUBS VSUBS sky130_fd_sc_hd__dfxtp_1_6/a_592_47#
+ VSUBS VSUBS sky130_fd_sc_hd__dfxtp_1_6/a_561_413# VSUBS VSUBS VSUBS sky130_fd_sc_hd__dfxtp_1
Xsky130_fd_sc_hd__mux2i_1_12 VSUBS VSUBS VSUBS VSUBS sky130_fd_sc_hd__mux2i_1_12/A0
+ sky130_fd_sc_hd__mux2i_1_12/Y VSUBS VSUBS VSUBS VSUBS VSUBS VSUBS sky130_fd_sc_hd__mux2i_1
Xsky130_fd_sc_hd__clkinv_1_10 VSUBS VSUBS VSUBS VSUBS VSUBS VSUBS sky130_fd_sc_hd__clkinv_1
Xsky130_fd_sc_hd__clkinvlp_4_0 VSUBS VSUBS VSUBS VSUBS VSUBS VSUBS sky130_fd_sc_hd__clkinvlp_4
Xsky130_fd_sc_hd__o21ai_0_28 VSUBS VSUBS VSUBS VSUBS VSUBS VSUBS VSUBS VSUBS VSUBS
+ sky130_fd_sc_hd__o21ai_0
Xsky130_fd_sc_hd__o21ai_0_39 VSUBS VSUBS VSUBS VSUBS sky130_fd_sc_hd__nand2_1_36/A
+ VSUBS VSUBS VSUBS VSUBS sky130_fd_sc_hd__o21ai_0
Xsky130_fd_sc_hd__o21ai_0_17 VSUBS VSUBS VSUBS VSUBS sky130_fd_sc_hd__o21ai_0_17/B1
+ VSUBS VSUBS VSUBS VSUBS sky130_fd_sc_hd__o21ai_0
Xsky130_fd_sc_hd__decap_4_92 VSUBS VSUBS VSUBS VSUBS sky130_fd_sc_hd__decap_4
Xsky130_fd_sc_hd__decap_4_70 VSUBS VSUBS VSUBS VSUBS sky130_fd_sc_hd__decap_4
Xsky130_fd_sc_hd__decap_8_161 VSUBS VSUBS VSUBS VSUBS sky130_fd_sc_hd__decap_8
Xsky130_fd_sc_hd__decap_8_150 VSUBS VSUBS VSUBS VSUBS sky130_fd_sc_hd__decap_8
Xsky130_fd_sc_hd__decap_4_81 VSUBS VSUBS VSUBS VSUBS sky130_fd_sc_hd__decap_4
Xsky130_fd_sc_hd__decap_8_172 VSUBS VSUBS VSUBS VSUBS sky130_fd_sc_hd__decap_8
Xsky130_fd_sc_hd__decap_8_194 VSUBS VSUBS VSUBS VSUBS sky130_fd_sc_hd__decap_8
Xsky130_fd_sc_hd__decap_8_183 VSUBS VSUBS VSUBS VSUBS sky130_fd_sc_hd__decap_8
Xsky130_fd_sc_hd__a21oi_1_49 VSUBS VSUBS VSUBS VSUBS VSUBS VSUBS VSUBS VSUBS VSUBS
+ sky130_fd_sc_hd__a21oi_1
Xsky130_fd_sc_hd__a21oi_1_27 VSUBS VSUBS VSUBS VSUBS VSUBS VSUBS VSUBS VSUBS VSUBS
+ sky130_fd_sc_hd__a21oi_1
Xsky130_fd_sc_hd__a21oi_1_38 VSUBS VSUBS VSUBS VSUBS VSUBS VSUBS VSUBS VSUBS VSUBS
+ sky130_fd_sc_hd__a21oi_1
Xsky130_fd_sc_hd__nor3_1_8 VSUBS VSUBS VSUBS VSUBS VSUBS VSUBS VSUBS VSUBS sky130_fd_sc_hd__nor3_1
Xsky130_fd_sc_hd__a21oi_1_16 VSUBS VSUBS VSUBS VSUBS sky130_fd_sc_hd__o21ai_0_20/B1
+ VSUBS VSUBS VSUBS VSUBS sky130_fd_sc_hd__a21oi_1
Xsky130_fd_sc_hd__decap_6_109 VSUBS VSUBS VSUBS VSUBS sky130_fd_sc_hd__decap_6
Xsky130_fd_sc_hd__decap_12_12 VSUBS VSUBS VSUBS VSUBS sky130_fd_sc_hd__decap_12
Xsky130_fd_sc_hd__decap_12_45 VSUBS VSUBS VSUBS VSUBS sky130_fd_sc_hd__decap_12
Xsky130_fd_sc_hd__decap_12_67 VSUBS VSUBS VSUBS VSUBS sky130_fd_sc_hd__decap_12
Xsky130_fd_sc_hd__decap_12_56 VSUBS VSUBS VSUBS VSUBS sky130_fd_sc_hd__decap_12
Xsky130_fd_sc_hd__decap_12_89 VSUBS VSUBS VSUBS VSUBS sky130_fd_sc_hd__decap_12
Xsky130_fd_sc_hd__decap_12_23 VSUBS VSUBS VSUBS VSUBS sky130_fd_sc_hd__decap_12
Xsky130_fd_sc_hd__decap_12_34 VSUBS VSUBS VSUBS VSUBS sky130_fd_sc_hd__decap_12
Xsky130_fd_sc_hd__decap_12_78 VSUBS VSUBS VSUBS VSUBS sky130_fd_sc_hd__decap_12
Xsky130_fd_sc_hd__decap_12_409 VSUBS VSUBS VSUBS VSUBS sky130_fd_sc_hd__decap_12
Xsky130_fd_sc_hd__dfxtp_1_100 VSUBS VSUBS VSUBS VSUBS VSUBS VSUBS VSUBS sky130_fd_sc_hd__dfxtp_1_100/a_975_413#
+ VSUBS VSUBS sky130_fd_sc_hd__dfxtp_1_100/a_592_47# VSUBS VSUBS sky130_fd_sc_hd__dfxtp_1_100/a_561_413#
+ VSUBS VSUBS VSUBS sky130_fd_sc_hd__dfxtp_1
Xsky130_fd_sc_hd__decap_12_998 VSUBS VSUBS VSUBS VSUBS sky130_fd_sc_hd__decap_12
Xsky130_fd_sc_hd__decap_12_987 VSUBS VSUBS VSUBS VSUBS sky130_fd_sc_hd__decap_12
Xsky130_fd_sc_hd__decap_12_954 VSUBS VSUBS VSUBS VSUBS sky130_fd_sc_hd__decap_12
Xsky130_fd_sc_hd__decap_12_965 VSUBS VSUBS VSUBS VSUBS sky130_fd_sc_hd__decap_12
Xsky130_fd_sc_hd__decap_12_921 VSUBS VSUBS VSUBS VSUBS sky130_fd_sc_hd__decap_12
Xsky130_fd_sc_hd__decap_12_910 VSUBS VSUBS VSUBS VSUBS sky130_fd_sc_hd__decap_12
Xsky130_fd_sc_hd__decap_12_932 VSUBS VSUBS VSUBS VSUBS sky130_fd_sc_hd__decap_12
Xsky130_fd_sc_hd__decap_12_976 VSUBS VSUBS VSUBS VSUBS sky130_fd_sc_hd__decap_12
Xsky130_fd_sc_hd__decap_12_943 VSUBS VSUBS VSUBS VSUBS sky130_fd_sc_hd__decap_12
Xsky130_fd_sc_hd__decap_12_217 VSUBS VSUBS VSUBS VSUBS sky130_fd_sc_hd__decap_12
Xsky130_fd_sc_hd__decap_12_228 VSUBS VSUBS VSUBS VSUBS sky130_fd_sc_hd__decap_12
Xsky130_fd_sc_hd__decap_12_239 VSUBS VSUBS VSUBS VSUBS sky130_fd_sc_hd__decap_12
Xsky130_fd_sc_hd__decap_12_206 VSUBS VSUBS VSUBS VSUBS sky130_fd_sc_hd__decap_12
Xsky130_fd_sc_hd__xor2_1_5 VSUBS VSUBS VSUBS VSUBS VSUBS VSUBS VSUBS VSUBS VSUBS sky130_fd_sc_hd__xor2_1
Xsky130_fd_sc_hd__and3_1_7 VSUBS VSUBS VSUBS VSUBS VSUBS VSUBS VSUBS VSUBS VSUBS sky130_fd_sc_hd__and3_1
Xsky130_fd_sc_hd__decap_12_773 VSUBS VSUBS VSUBS VSUBS sky130_fd_sc_hd__decap_12
Xsky130_fd_sc_hd__decap_12_762 VSUBS VSUBS VSUBS VSUBS sky130_fd_sc_hd__decap_12
Xsky130_fd_sc_hd__decap_12_784 VSUBS VSUBS VSUBS VSUBS sky130_fd_sc_hd__decap_12
Xsky130_fd_sc_hd__decap_12_751 VSUBS VSUBS VSUBS VSUBS sky130_fd_sc_hd__decap_12
Xsky130_fd_sc_hd__decap_12_740 VSUBS VSUBS VSUBS VSUBS sky130_fd_sc_hd__decap_12
Xsky130_fd_sc_hd__decap_12_795 VSUBS VSUBS VSUBS VSUBS sky130_fd_sc_hd__decap_12
Xsky130_fd_sc_hd__nor3_1_11 VSUBS VSUBS VSUBS VSUBS VSUBS VSUBS VSUBS VSUBS sky130_fd_sc_hd__nor3_1
Xsky130_fd_sc_hd__decap_6_38 VSUBS VSUBS VSUBS VSUBS sky130_fd_sc_hd__decap_6
Xsky130_fd_sc_hd__decap_6_27 VSUBS VSUBS VSUBS VSUBS sky130_fd_sc_hd__decap_6
Xsky130_fd_sc_hd__decap_6_16 VSUBS VSUBS VSUBS VSUBS sky130_fd_sc_hd__decap_6
Xsky130_fd_sc_hd__decap_6_49 VSUBS VSUBS VSUBS VSUBS sky130_fd_sc_hd__decap_6
Xsky130_fd_sc_hd__o21ai_0_7 VSUBS VSUBS VSUBS VSUBS VSUBS VSUBS VSUBS VSUBS VSUBS
+ sky130_fd_sc_hd__o21ai_0
Xsky130_fd_sc_hd__a22oi_1_10 VSUBS VSUBS VSUBS VSUBS VSUBS VSUBS VSUBS VSUBS VSUBS
+ sky130_fd_sc_hd__a22oi_1_10/a_381_47# VSUBS sky130_fd_sc_hd__a22oi_1
Xsky130_fd_sc_hd__decap_12_1057 VSUBS VSUBS VSUBS VSUBS sky130_fd_sc_hd__decap_12
Xsky130_fd_sc_hd__decap_12_1068 VSUBS VSUBS VSUBS VSUBS sky130_fd_sc_hd__decap_12
Xsky130_fd_sc_hd__decap_12_1013 VSUBS VSUBS VSUBS VSUBS sky130_fd_sc_hd__decap_12
Xsky130_fd_sc_hd__decap_12_1002 VSUBS VSUBS VSUBS VSUBS sky130_fd_sc_hd__decap_12
Xsky130_fd_sc_hd__decap_12_1035 VSUBS VSUBS VSUBS VSUBS sky130_fd_sc_hd__decap_12
Xsky130_fd_sc_hd__decap_12_1024 VSUBS VSUBS VSUBS VSUBS sky130_fd_sc_hd__decap_12
Xsky130_fd_sc_hd__decap_12_1046 VSUBS VSUBS VSUBS VSUBS sky130_fd_sc_hd__decap_12
Xsky130_fd_sc_hd__decap_12_1079 VSUBS VSUBS VSUBS VSUBS sky130_fd_sc_hd__decap_12
Xsky130_fd_sc_hd__decap_12_570 VSUBS VSUBS VSUBS VSUBS sky130_fd_sc_hd__decap_12
Xsky130_fd_sc_hd__decap_12_581 VSUBS VSUBS VSUBS VSUBS sky130_fd_sc_hd__decap_12
Xsky130_fd_sc_hd__decap_12_592 VSUBS VSUBS VSUBS VSUBS sky130_fd_sc_hd__decap_12
Xsky130_fd_sc_hd__dfxtp_1_56 VSUBS VSUBS VSUBS VSUBS VSUBS VSUBS VSUBS sky130_fd_sc_hd__dfxtp_1_56/a_975_413#
+ VSUBS VSUBS sky130_fd_sc_hd__dfxtp_1_56/a_592_47# VSUBS VSUBS sky130_fd_sc_hd__dfxtp_1_56/a_561_413#
+ VSUBS VSUBS VSUBS sky130_fd_sc_hd__dfxtp_1
Xsky130_fd_sc_hd__dfxtp_1_67 VSUBS VSUBS VSUBS VSUBS VSUBS VSUBS VSUBS sky130_fd_sc_hd__dfxtp_1_67/a_975_413#
+ VSUBS VSUBS sky130_fd_sc_hd__dfxtp_1_67/a_592_47# VSUBS VSUBS sky130_fd_sc_hd__dfxtp_1_67/a_561_413#
+ VSUBS VSUBS VSUBS sky130_fd_sc_hd__dfxtp_1
Xsky130_fd_sc_hd__dfxtp_1_34 VSUBS VSUBS VSUBS VSUBS VSUBS VSUBS VSUBS sky130_fd_sc_hd__dfxtp_1_34/a_975_413#
+ VSUBS VSUBS sky130_fd_sc_hd__dfxtp_1_34/a_592_47# VSUBS VSUBS sky130_fd_sc_hd__dfxtp_1_34/a_561_413#
+ VSUBS VSUBS VSUBS sky130_fd_sc_hd__dfxtp_1
Xsky130_fd_sc_hd__dfxtp_1_12 VSUBS VSUBS VSUBS VSUBS VSUBS VSUBS VSUBS sky130_fd_sc_hd__dfxtp_1_12/a_975_413#
+ VSUBS VSUBS sky130_fd_sc_hd__dfxtp_1_12/a_592_47# VSUBS VSUBS sky130_fd_sc_hd__dfxtp_1_12/a_561_413#
+ VSUBS VSUBS VSUBS sky130_fd_sc_hd__dfxtp_1
Xsky130_fd_sc_hd__dfxtp_1_23 VSUBS VSUBS VSUBS VSUBS VSUBS VSUBS VSUBS sky130_fd_sc_hd__dfxtp_1_23/a_975_413#
+ VSUBS VSUBS sky130_fd_sc_hd__dfxtp_1_23/a_592_47# VSUBS VSUBS sky130_fd_sc_hd__dfxtp_1_23/a_561_413#
+ VSUBS VSUBS VSUBS sky130_fd_sc_hd__dfxtp_1
Xsky130_fd_sc_hd__dfxtp_1_45 VSUBS VSUBS VSUBS VSUBS VSUBS VSUBS VSUBS sky130_fd_sc_hd__dfxtp_1_45/a_975_413#
+ VSUBS VSUBS sky130_fd_sc_hd__dfxtp_1_45/a_592_47# VSUBS VSUBS sky130_fd_sc_hd__dfxtp_1_45/a_561_413#
+ VSUBS VSUBS VSUBS sky130_fd_sc_hd__dfxtp_1
Xsky130_fd_sc_hd__dfxtp_1_78 VSUBS VSUBS VSUBS VSUBS sky130_fd_sc_hd__dfxtp_1_78/CLK
+ sky130_fd_sc_hd__dfxtp_1_78/D VSUBS sky130_fd_sc_hd__dfxtp_1_78/a_975_413# VSUBS
+ VSUBS sky130_fd_sc_hd__dfxtp_1_78/a_592_47# VSUBS VSUBS sky130_fd_sc_hd__dfxtp_1_78/a_561_413#
+ VSUBS sky130_fd_sc_hd__dfxtp_1_78/a_381_47# VSUBS sky130_fd_sc_hd__dfxtp_1
Xsky130_fd_sc_hd__dfxtp_1_89 VSUBS VSUBS VSUBS VSUBS VSUBS sky130_fd_sc_hd__dfxtp_1_89/D
+ VSUBS sky130_fd_sc_hd__dfxtp_1_89/a_975_413# VSUBS VSUBS sky130_fd_sc_hd__dfxtp_1_89/a_592_47#
+ VSUBS VSUBS sky130_fd_sc_hd__dfxtp_1_89/a_561_413# VSUBS VSUBS VSUBS sky130_fd_sc_hd__dfxtp_1
Xsky130_fd_sc_hd__decap_3_17 VSUBS VSUBS VSUBS VSUBS sky130_fd_sc_hd__decap_3
Xsky130_fd_sc_hd__decap_3_28 VSUBS VSUBS VSUBS VSUBS sky130_fd_sc_hd__decap_3
Xsky130_fd_sc_hd__decap_3_39 VSUBS VSUBS VSUBS VSUBS sky130_fd_sc_hd__decap_3
Xsky130_fd_sc_hd__dfxtp_1_7 VSUBS VSUBS VSUBS VSUBS VSUBS VSUBS VSUBS sky130_fd_sc_hd__dfxtp_1_7/a_975_413#
+ VSUBS VSUBS VSUBS VSUBS VSUBS VSUBS VSUBS VSUBS VSUBS sky130_fd_sc_hd__dfxtp_1
Xsky130_fd_sc_hd__mux2i_1_13 VSUBS VSUBS VSUBS VSUBS VSUBS VSUBS VSUBS VSUBS VSUBS
+ VSUBS VSUBS VSUBS sky130_fd_sc_hd__mux2i_1
Xsky130_fd_sc_hd__clkinv_1_11 VSUBS VSUBS VSUBS VSUBS VSUBS VSUBS sky130_fd_sc_hd__clkinv_1
Xsky130_fd_sc_hd__buf_8_0 VSUBS VSUBS VSUBS VSUBS VSUBS VSUBS VSUBS sky130_fd_sc_hd__buf_8
Xsky130_fd_sc_hd__o21ai_0_29 VSUBS VSUBS VSUBS VSUBS VSUBS VSUBS VSUBS VSUBS VSUBS
+ sky130_fd_sc_hd__o21ai_0
Xsky130_fd_sc_hd__o21ai_0_18 VSUBS VSUBS VSUBS VSUBS VSUBS sky130_fd_sc_hd__o21ai_0_19/A1
+ VSUBS VSUBS VSUBS sky130_fd_sc_hd__o21ai_0
Xsky130_fd_sc_hd__decap_4_60 VSUBS VSUBS VSUBS VSUBS sky130_fd_sc_hd__decap_4
Xsky130_fd_sc_hd__decap_8_162 VSUBS VSUBS VSUBS VSUBS sky130_fd_sc_hd__decap_8
Xsky130_fd_sc_hd__decap_8_173 VSUBS VSUBS VSUBS VSUBS sky130_fd_sc_hd__decap_8
Xsky130_fd_sc_hd__decap_4_82 VSUBS VSUBS VSUBS VSUBS sky130_fd_sc_hd__decap_4
Xsky130_fd_sc_hd__decap_4_93 VSUBS VSUBS VSUBS VSUBS sky130_fd_sc_hd__decap_4
Xsky130_fd_sc_hd__decap_8_195 VSUBS VSUBS VSUBS VSUBS sky130_fd_sc_hd__decap_8
Xsky130_fd_sc_hd__decap_8_140 VSUBS VSUBS VSUBS VSUBS sky130_fd_sc_hd__decap_8
Xsky130_fd_sc_hd__decap_8_151 VSUBS VSUBS VSUBS VSUBS sky130_fd_sc_hd__decap_8
Xsky130_fd_sc_hd__decap_4_71 VSUBS VSUBS VSUBS VSUBS sky130_fd_sc_hd__decap_4
Xsky130_fd_sc_hd__decap_8_184 VSUBS VSUBS VSUBS VSUBS sky130_fd_sc_hd__decap_8
Xsky130_fd_sc_hd__a21oi_1_28 VSUBS VSUBS VSUBS VSUBS VSUBS VSUBS VSUBS VSUBS VSUBS
+ sky130_fd_sc_hd__a21oi_1
Xsky130_fd_sc_hd__a21oi_1_17 VSUBS VSUBS VSUBS VSUBS VSUBS VSUBS VSUBS VSUBS VSUBS
+ sky130_fd_sc_hd__a21oi_1
Xsky130_fd_sc_hd__nor3_1_9 VSUBS VSUBS VSUBS VSUBS VSUBS VSUBS VSUBS VSUBS sky130_fd_sc_hd__nor3_1
Xsky130_fd_sc_hd__a21oi_1_39 VSUBS VSUBS VSUBS VSUBS VSUBS VSUBS VSUBS VSUBS VSUBS
+ sky130_fd_sc_hd__a21oi_1
Xsky130_fd_sc_hd__decap_12_46 VSUBS VSUBS VSUBS VSUBS sky130_fd_sc_hd__decap_12
Xsky130_fd_sc_hd__decap_12_13 VSUBS VSUBS VSUBS VSUBS sky130_fd_sc_hd__decap_12
Xsky130_fd_sc_hd__decap_12_68 VSUBS VSUBS VSUBS VSUBS sky130_fd_sc_hd__decap_12
Xsky130_fd_sc_hd__decap_12_57 VSUBS VSUBS VSUBS VSUBS sky130_fd_sc_hd__decap_12
Xsky130_fd_sc_hd__decap_12_24 VSUBS VSUBS VSUBS VSUBS sky130_fd_sc_hd__decap_12
Xsky130_fd_sc_hd__decap_12_79 VSUBS VSUBS VSUBS VSUBS sky130_fd_sc_hd__decap_12
Xsky130_fd_sc_hd__decap_12_35 VSUBS VSUBS VSUBS VSUBS sky130_fd_sc_hd__decap_12
Xsky130_fd_sc_hd__dfxtp_1_101 VSUBS VSUBS VSUBS VSUBS VSUBS sky130_fd_sc_hd__dfxtp_1_101/D
+ VSUBS sky130_fd_sc_hd__dfxtp_1_101/a_975_413# VSUBS VSUBS sky130_fd_sc_hd__dfxtp_1_101/a_592_47#
+ VSUBS VSUBS sky130_fd_sc_hd__dfxtp_1_101/a_561_413# VSUBS VSUBS VSUBS sky130_fd_sc_hd__dfxtp_1
Xsky130_fd_sc_hd__decap_12_911 VSUBS VSUBS VSUBS VSUBS sky130_fd_sc_hd__decap_12
Xsky130_fd_sc_hd__decap_12_900 VSUBS VSUBS VSUBS VSUBS sky130_fd_sc_hd__decap_12
Xsky130_fd_sc_hd__decap_12_999 VSUBS VSUBS VSUBS VSUBS sky130_fd_sc_hd__decap_12
Xsky130_fd_sc_hd__decap_12_988 VSUBS VSUBS VSUBS VSUBS sky130_fd_sc_hd__decap_12
Xsky130_fd_sc_hd__decap_12_955 VSUBS VSUBS VSUBS VSUBS sky130_fd_sc_hd__decap_12
Xsky130_fd_sc_hd__decap_12_966 VSUBS VSUBS VSUBS VSUBS sky130_fd_sc_hd__decap_12
Xsky130_fd_sc_hd__decap_12_933 VSUBS VSUBS VSUBS VSUBS sky130_fd_sc_hd__decap_12
Xsky130_fd_sc_hd__decap_12_922 VSUBS VSUBS VSUBS VSUBS sky130_fd_sc_hd__decap_12
Xsky130_fd_sc_hd__decap_12_944 VSUBS VSUBS VSUBS VSUBS sky130_fd_sc_hd__decap_12
Xsky130_fd_sc_hd__decap_12_977 VSUBS VSUBS VSUBS VSUBS sky130_fd_sc_hd__decap_12
Xsky130_fd_sc_hd__o31a_1_0 VSUBS VSUBS VSUBS VSUBS VSUBS VSUBS VSUBS VSUBS VSUBS VSUBS
+ VSUBS sky130_fd_sc_hd__o31a_1
Xsky130_fd_sc_hd__decap_12_207 VSUBS VSUBS VSUBS VSUBS sky130_fd_sc_hd__decap_12
Xsky130_fd_sc_hd__decap_12_218 VSUBS VSUBS VSUBS VSUBS sky130_fd_sc_hd__decap_12
Xsky130_fd_sc_hd__decap_12_229 VSUBS VSUBS VSUBS VSUBS sky130_fd_sc_hd__decap_12
Xsky130_fd_sc_hd__xor2_1_6 VSUBS VSUBS VSUBS VSUBS VSUBS VSUBS VSUBS VSUBS VSUBS sky130_fd_sc_hd__xor2_1
Xsky130_fd_sc_hd__decap_12_741 VSUBS VSUBS VSUBS VSUBS sky130_fd_sc_hd__decap_12
Xsky130_fd_sc_hd__decap_12_752 VSUBS VSUBS VSUBS VSUBS sky130_fd_sc_hd__decap_12
Xsky130_fd_sc_hd__decap_12_730 VSUBS VSUBS VSUBS VSUBS sky130_fd_sc_hd__decap_12
Xsky130_fd_sc_hd__nor3_1_12 VSUBS VSUBS VSUBS VSUBS VSUBS VSUBS VSUBS VSUBS sky130_fd_sc_hd__nor3_1
Xsky130_fd_sc_hd__decap_12_774 VSUBS VSUBS VSUBS VSUBS sky130_fd_sc_hd__decap_12
Xsky130_fd_sc_hd__decap_12_763 VSUBS VSUBS VSUBS VSUBS sky130_fd_sc_hd__decap_12
Xsky130_fd_sc_hd__decap_12_796 VSUBS VSUBS VSUBS VSUBS sky130_fd_sc_hd__decap_12
Xsky130_fd_sc_hd__decap_12_785 VSUBS VSUBS VSUBS VSUBS sky130_fd_sc_hd__decap_12
Xsky130_fd_sc_hd__decap_6_28 VSUBS VSUBS VSUBS VSUBS sky130_fd_sc_hd__decap_6
Xsky130_fd_sc_hd__decap_6_39 VSUBS VSUBS VSUBS VSUBS sky130_fd_sc_hd__decap_6
Xsky130_fd_sc_hd__decap_6_17 VSUBS VSUBS VSUBS VSUBS sky130_fd_sc_hd__decap_6
Xsky130_fd_sc_hd__o21ai_0_8 VSUBS VSUBS VSUBS VSUBS VSUBS VSUBS VSUBS VSUBS VSUBS
+ sky130_fd_sc_hd__o21ai_0
Xsky130_fd_sc_hd__a22oi_1_11 VSUBS VSUBS VSUBS VSUBS VSUBS VSUBS VSUBS VSUBS VSUBS
+ sky130_fd_sc_hd__a22oi_1_11/a_381_47# VSUBS sky130_fd_sc_hd__a22oi_1
Xsky130_fd_sc_hd__dfrtp_1_0 VSUBS VSUBS VSUBS VSUBS VSUBS VSUBS VSUBS VSUBS VSUBS
+ VSUBS VSUBS VSUBS VSUBS VSUBS VSUBS VSUBS sky130_fd_sc_hd__dfrtp_1
Xsky130_fd_sc_hd__decap_12_1014 VSUBS VSUBS VSUBS VSUBS sky130_fd_sc_hd__decap_12
Xsky130_fd_sc_hd__decap_12_1003 VSUBS VSUBS VSUBS VSUBS sky130_fd_sc_hd__decap_12
Xsky130_fd_sc_hd__decap_12_1069 VSUBS VSUBS VSUBS VSUBS sky130_fd_sc_hd__decap_12
Xsky130_fd_sc_hd__decap_12_1058 VSUBS VSUBS VSUBS VSUBS sky130_fd_sc_hd__decap_12
Xsky130_fd_sc_hd__decap_12_1036 VSUBS VSUBS VSUBS VSUBS sky130_fd_sc_hd__decap_12
Xsky130_fd_sc_hd__decap_12_1025 VSUBS VSUBS VSUBS VSUBS sky130_fd_sc_hd__decap_12
Xsky130_fd_sc_hd__decap_12_1047 VSUBS VSUBS VSUBS VSUBS sky130_fd_sc_hd__decap_12
Xsky130_fd_sc_hd__decap_12_582 VSUBS VSUBS VSUBS VSUBS sky130_fd_sc_hd__decap_12
Xsky130_fd_sc_hd__decap_12_593 VSUBS VSUBS VSUBS VSUBS sky130_fd_sc_hd__decap_12
Xsky130_fd_sc_hd__decap_12_560 VSUBS VSUBS VSUBS VSUBS sky130_fd_sc_hd__decap_12
Xsky130_fd_sc_hd__decap_12_571 VSUBS VSUBS VSUBS VSUBS sky130_fd_sc_hd__decap_12
Xsky130_fd_sc_hd__dfxtp_1_79 VSUBS VSUBS VSUBS VSUBS sky130_fd_sc_hd__dfxtp_1_79/CLK
+ VSUBS VSUBS sky130_fd_sc_hd__dfxtp_1_79/a_975_413# VSUBS VSUBS VSUBS VSUBS VSUBS
+ VSUBS VSUBS sky130_fd_sc_hd__dfxtp_1_79/a_381_47# VSUBS sky130_fd_sc_hd__dfxtp_1
Xsky130_fd_sc_hd__dfxtp_1_68 VSUBS VSUBS VSUBS VSUBS VSUBS VSUBS VSUBS sky130_fd_sc_hd__dfxtp_1_68/a_975_413#
+ VSUBS VSUBS sky130_fd_sc_hd__dfxtp_1_68/a_592_47# VSUBS VSUBS sky130_fd_sc_hd__dfxtp_1_68/a_561_413#
+ VSUBS VSUBS VSUBS sky130_fd_sc_hd__dfxtp_1
Xsky130_fd_sc_hd__dfxtp_1_46 VSUBS VSUBS VSUBS VSUBS VSUBS VSUBS VSUBS sky130_fd_sc_hd__dfxtp_1_46/a_975_413#
+ VSUBS VSUBS sky130_fd_sc_hd__dfxtp_1_46/a_592_47# VSUBS VSUBS sky130_fd_sc_hd__dfxtp_1_46/a_561_413#
+ VSUBS VSUBS VSUBS sky130_fd_sc_hd__dfxtp_1
Xsky130_fd_sc_hd__dfxtp_1_57 VSUBS VSUBS VSUBS VSUBS VSUBS VSUBS VSUBS sky130_fd_sc_hd__dfxtp_1_57/a_975_413#
+ VSUBS VSUBS sky130_fd_sc_hd__dfxtp_1_57/a_592_47# VSUBS VSUBS sky130_fd_sc_hd__dfxtp_1_57/a_561_413#
+ VSUBS VSUBS VSUBS sky130_fd_sc_hd__dfxtp_1
Xsky130_fd_sc_hd__dfxtp_1_35 VSUBS VSUBS VSUBS VSUBS VSUBS VSUBS VSUBS sky130_fd_sc_hd__dfxtp_1_35/a_975_413#
+ VSUBS VSUBS sky130_fd_sc_hd__dfxtp_1_35/a_592_47# VSUBS VSUBS sky130_fd_sc_hd__dfxtp_1_35/a_561_413#
+ VSUBS VSUBS VSUBS sky130_fd_sc_hd__dfxtp_1
Xsky130_fd_sc_hd__dfxtp_1_13 VSUBS VSUBS VSUBS VSUBS VSUBS VSUBS VSUBS sky130_fd_sc_hd__dfxtp_1_13/a_975_413#
+ VSUBS VSUBS sky130_fd_sc_hd__dfxtp_1_13/a_592_47# VSUBS VSUBS sky130_fd_sc_hd__dfxtp_1_13/a_561_413#
+ VSUBS VSUBS VSUBS sky130_fd_sc_hd__dfxtp_1
Xsky130_fd_sc_hd__dfxtp_1_24 VSUBS VSUBS VSUBS VSUBS VSUBS VSUBS VSUBS sky130_fd_sc_hd__dfxtp_1_24/a_975_413#
+ VSUBS VSUBS sky130_fd_sc_hd__dfxtp_1_24/a_592_47# VSUBS VSUBS sky130_fd_sc_hd__dfxtp_1_24/a_561_413#
+ VSUBS VSUBS VSUBS sky130_fd_sc_hd__dfxtp_1
Xsky130_fd_sc_hd__decap_3_18 VSUBS VSUBS VSUBS VSUBS sky130_fd_sc_hd__decap_3
Xsky130_fd_sc_hd__decap_3_29 VSUBS VSUBS VSUBS VSUBS sky130_fd_sc_hd__decap_3
Xsky130_fd_sc_hd__decap_12_390 VSUBS VSUBS VSUBS VSUBS sky130_fd_sc_hd__decap_12
Xsky130_fd_sc_hd__dfxtp_1_8 VSUBS VSUBS VSUBS VSUBS sky130_fd_sc_hd__dfxtp_1_8/CLK
+ VSUBS VSUBS sky130_fd_sc_hd__dfxtp_1_8/a_975_413# VSUBS VSUBS sky130_fd_sc_hd__dfxtp_1_8/a_592_47#
+ VSUBS VSUBS sky130_fd_sc_hd__dfxtp_1_8/a_561_413# VSUBS VSUBS VSUBS sky130_fd_sc_hd__dfxtp_1
Xsky130_fd_sc_hd__clkinv_1_12 VSUBS VSUBS VSUBS VSUBS VSUBS VSUBS sky130_fd_sc_hd__clkinv_1
Xsky130_fd_sc_hd__mux2i_1_14 VSUBS VSUBS VSUBS VSUBS VSUBS VSUBS VSUBS VSUBS VSUBS
+ VSUBS VSUBS VSUBS sky130_fd_sc_hd__mux2i_1
Xsky130_fd_sc_hd__o21ai_0_19 VSUBS VSUBS VSUBS VSUBS VSUBS sky130_fd_sc_hd__o21ai_0_19/A1
+ VSUBS VSUBS VSUBS sky130_fd_sc_hd__o21ai_0
Xsky130_fd_sc_hd__decap_4_83 VSUBS VSUBS VSUBS VSUBS sky130_fd_sc_hd__decap_4
Xsky130_fd_sc_hd__decap_4_61 VSUBS VSUBS VSUBS VSUBS sky130_fd_sc_hd__decap_4
Xsky130_fd_sc_hd__decap_4_72 VSUBS VSUBS VSUBS VSUBS sky130_fd_sc_hd__decap_4
Xsky130_fd_sc_hd__decap_4_50 VSUBS VSUBS VSUBS VSUBS sky130_fd_sc_hd__decap_4
Xsky130_fd_sc_hd__decap_8_174 VSUBS VSUBS VSUBS VSUBS sky130_fd_sc_hd__decap_8
Xsky130_fd_sc_hd__decap_8_163 VSUBS VSUBS VSUBS VSUBS sky130_fd_sc_hd__decap_8
Xsky130_fd_sc_hd__decap_4_94 VSUBS VSUBS VSUBS VSUBS sky130_fd_sc_hd__decap_4
Xsky130_fd_sc_hd__decap_8_196 VSUBS VSUBS VSUBS VSUBS sky130_fd_sc_hd__decap_8
Xsky130_fd_sc_hd__decap_8_152 VSUBS VSUBS VSUBS VSUBS sky130_fd_sc_hd__decap_8
Xsky130_fd_sc_hd__decap_8_141 VSUBS VSUBS VSUBS VSUBS sky130_fd_sc_hd__decap_8
Xsky130_fd_sc_hd__decap_8_185 VSUBS VSUBS VSUBS VSUBS sky130_fd_sc_hd__decap_8
Xsky130_fd_sc_hd__decap_8_130 VSUBS VSUBS VSUBS VSUBS sky130_fd_sc_hd__decap_8
Xsky130_fd_sc_hd__a21oi_1_29 VSUBS VSUBS VSUBS VSUBS VSUBS VSUBS VSUBS VSUBS VSUBS
+ sky130_fd_sc_hd__a21oi_1
Xsky130_fd_sc_hd__a21oi_1_18 VSUBS VSUBS VSUBS VSUBS VSUBS VSUBS VSUBS VSUBS VSUBS
+ sky130_fd_sc_hd__a21oi_1
Xsky130_fd_sc_hd__decap_12_14 VSUBS VSUBS VSUBS VSUBS sky130_fd_sc_hd__decap_12
Xsky130_fd_sc_hd__decap_12_25 VSUBS VSUBS VSUBS VSUBS sky130_fd_sc_hd__decap_12
Xsky130_fd_sc_hd__decap_12_58 VSUBS VSUBS VSUBS VSUBS sky130_fd_sc_hd__decap_12
Xsky130_fd_sc_hd__decap_12_69 VSUBS VSUBS VSUBS VSUBS sky130_fd_sc_hd__decap_12
Xsky130_fd_sc_hd__decap_12_47 VSUBS VSUBS VSUBS VSUBS sky130_fd_sc_hd__decap_12
Xsky130_fd_sc_hd__decap_12_36 VSUBS VSUBS VSUBS VSUBS sky130_fd_sc_hd__decap_12
Xsky130_fd_sc_hd__decap_12_912 VSUBS VSUBS VSUBS VSUBS sky130_fd_sc_hd__decap_12
Xsky130_fd_sc_hd__decap_12_934 VSUBS VSUBS VSUBS VSUBS sky130_fd_sc_hd__decap_12
Xsky130_fd_sc_hd__decap_12_901 VSUBS VSUBS VSUBS VSUBS sky130_fd_sc_hd__decap_12
Xsky130_fd_sc_hd__decap_12_923 VSUBS VSUBS VSUBS VSUBS sky130_fd_sc_hd__decap_12
Xsky130_fd_sc_hd__decap_12_945 VSUBS VSUBS VSUBS VSUBS sky130_fd_sc_hd__decap_12
Xsky130_fd_sc_hd__decap_12_989 VSUBS VSUBS VSUBS VSUBS sky130_fd_sc_hd__decap_12
Xsky130_fd_sc_hd__decap_12_956 VSUBS VSUBS VSUBS VSUBS sky130_fd_sc_hd__decap_12
Xsky130_fd_sc_hd__decap_12_967 VSUBS VSUBS VSUBS VSUBS sky130_fd_sc_hd__decap_12
Xsky130_fd_sc_hd__decap_12_978 VSUBS VSUBS VSUBS VSUBS sky130_fd_sc_hd__decap_12
Xsky130_fd_sc_hd__o31a_1_1 VSUBS VSUBS VSUBS VSUBS VSUBS VSUBS VSUBS VSUBS VSUBS VSUBS
+ VSUBS sky130_fd_sc_hd__o31a_1
Xsky130_fd_sc_hd__decap_12_208 VSUBS VSUBS VSUBS VSUBS sky130_fd_sc_hd__decap_12
Xsky130_fd_sc_hd__decap_12_219 VSUBS VSUBS VSUBS VSUBS sky130_fd_sc_hd__decap_12
Xsky130_fd_sc_hd__xor2_1_7 VSUBS VSUBS VSUBS VSUBS VSUBS VSUBS VSUBS VSUBS VSUBS sky130_fd_sc_hd__xor2_1
Xsky130_fd_sc_hd__decap_12_742 VSUBS VSUBS VSUBS VSUBS sky130_fd_sc_hd__decap_12
Xsky130_fd_sc_hd__decap_12_764 VSUBS VSUBS VSUBS VSUBS sky130_fd_sc_hd__decap_12
Xsky130_fd_sc_hd__decap_12_786 VSUBS VSUBS VSUBS VSUBS sky130_fd_sc_hd__decap_12
Xsky130_fd_sc_hd__decap_12_775 VSUBS VSUBS VSUBS VSUBS sky130_fd_sc_hd__decap_12
Xsky130_fd_sc_hd__decap_12_753 VSUBS VSUBS VSUBS VSUBS sky130_fd_sc_hd__decap_12
Xsky130_fd_sc_hd__decap_12_731 VSUBS VSUBS VSUBS VSUBS sky130_fd_sc_hd__decap_12
Xsky130_fd_sc_hd__decap_12_720 VSUBS VSUBS VSUBS VSUBS sky130_fd_sc_hd__decap_12
Xsky130_fd_sc_hd__nor3_1_13 VSUBS VSUBS VSUBS VSUBS VSUBS VSUBS VSUBS VSUBS sky130_fd_sc_hd__nor3_1
Xsky130_fd_sc_hd__decap_12_797 VSUBS VSUBS VSUBS VSUBS sky130_fd_sc_hd__decap_12
Xsky130_fd_sc_hd__decap_6_29 VSUBS VSUBS VSUBS VSUBS sky130_fd_sc_hd__decap_6
Xsky130_fd_sc_hd__decap_6_18 VSUBS VSUBS VSUBS VSUBS sky130_fd_sc_hd__decap_6
Xsky130_fd_sc_hd__o21ai_0_9 VSUBS VSUBS VSUBS VSUBS VSUBS VSUBS VSUBS VSUBS VSUBS
+ sky130_fd_sc_hd__o21ai_0
Xsky130_fd_sc_hd__a22oi_1_12 VSUBS VSUBS VSUBS VSUBS VSUBS VSUBS VSUBS VSUBS VSUBS
+ sky130_fd_sc_hd__a22oi_1_12/a_381_47# VSUBS sky130_fd_sc_hd__a22oi_1
Xsky130_fd_sc_hd__decap_12_1015 VSUBS VSUBS VSUBS VSUBS sky130_fd_sc_hd__decap_12
Xsky130_fd_sc_hd__decap_12_1004 VSUBS VSUBS VSUBS VSUBS sky130_fd_sc_hd__decap_12
Xsky130_fd_sc_hd__decap_12_1026 VSUBS VSUBS VSUBS VSUBS sky130_fd_sc_hd__decap_12
Xsky130_fd_sc_hd__decap_12_1059 VSUBS VSUBS VSUBS VSUBS sky130_fd_sc_hd__decap_12
Xsky130_fd_sc_hd__decap_12_1037 VSUBS VSUBS VSUBS VSUBS sky130_fd_sc_hd__decap_12
Xsky130_fd_sc_hd__decap_12_1048 VSUBS VSUBS VSUBS VSUBS sky130_fd_sc_hd__decap_12
Xsky130_fd_sc_hd__o21a_1_0 VSUBS VSUBS VSUBS VSUBS VSUBS VSUBS VSUBS VSUBS VSUBS VSUBS
+ sky130_fd_sc_hd__o21a_1
Xsky130_fd_sc_hd__decap_12_583 VSUBS VSUBS VSUBS VSUBS sky130_fd_sc_hd__decap_12
Xsky130_fd_sc_hd__decap_12_594 VSUBS VSUBS VSUBS VSUBS sky130_fd_sc_hd__decap_12
Xsky130_fd_sc_hd__decap_12_572 VSUBS VSUBS VSUBS VSUBS sky130_fd_sc_hd__decap_12
Xsky130_fd_sc_hd__decap_12_561 VSUBS VSUBS VSUBS VSUBS sky130_fd_sc_hd__decap_12
Xsky130_fd_sc_hd__decap_12_550 VSUBS VSUBS VSUBS VSUBS sky130_fd_sc_hd__decap_12
Xsky130_fd_sc_hd__dfxtp_1_69 VSUBS VSUBS VSUBS VSUBS VSUBS VSUBS VSUBS sky130_fd_sc_hd__dfxtp_1_69/a_975_413#
+ VSUBS VSUBS sky130_fd_sc_hd__dfxtp_1_69/a_592_47# VSUBS VSUBS sky130_fd_sc_hd__dfxtp_1_69/a_561_413#
+ VSUBS VSUBS VSUBS sky130_fd_sc_hd__dfxtp_1
Xsky130_fd_sc_hd__dfxtp_1_58 VSUBS VSUBS VSUBS VSUBS VSUBS VSUBS VSUBS sky130_fd_sc_hd__dfxtp_1_58/a_975_413#
+ VSUBS VSUBS sky130_fd_sc_hd__dfxtp_1_58/a_592_47# VSUBS VSUBS sky130_fd_sc_hd__dfxtp_1_58/a_561_413#
+ VSUBS VSUBS VSUBS sky130_fd_sc_hd__dfxtp_1
Xsky130_fd_sc_hd__dfxtp_1_47 VSUBS VSUBS VSUBS VSUBS VSUBS VSUBS VSUBS sky130_fd_sc_hd__dfxtp_1_47/a_975_413#
+ VSUBS VSUBS sky130_fd_sc_hd__dfxtp_1_47/a_592_47# VSUBS VSUBS sky130_fd_sc_hd__dfxtp_1_47/a_561_413#
+ VSUBS VSUBS VSUBS sky130_fd_sc_hd__dfxtp_1
Xsky130_fd_sc_hd__dfxtp_1_14 VSUBS VSUBS VSUBS VSUBS VSUBS VSUBS VSUBS sky130_fd_sc_hd__dfxtp_1_14/a_975_413#
+ VSUBS VSUBS sky130_fd_sc_hd__dfxtp_1_14/a_592_47# VSUBS VSUBS sky130_fd_sc_hd__dfxtp_1_14/a_561_413#
+ VSUBS VSUBS VSUBS sky130_fd_sc_hd__dfxtp_1
Xsky130_fd_sc_hd__dfxtp_1_36 VSUBS VSUBS VSUBS VSUBS VSUBS VSUBS VSUBS sky130_fd_sc_hd__dfxtp_1_36/a_975_413#
+ VSUBS VSUBS sky130_fd_sc_hd__dfxtp_1_36/a_592_47# VSUBS VSUBS sky130_fd_sc_hd__dfxtp_1_36/a_561_413#
+ VSUBS VSUBS VSUBS sky130_fd_sc_hd__dfxtp_1
Xsky130_fd_sc_hd__dfxtp_1_25 VSUBS VSUBS VSUBS VSUBS VSUBS VSUBS VSUBS sky130_fd_sc_hd__dfxtp_1_25/a_975_413#
+ VSUBS VSUBS VSUBS VSUBS VSUBS VSUBS VSUBS VSUBS VSUBS sky130_fd_sc_hd__dfxtp_1
Xsky130_fd_sc_hd__decap_3_19 VSUBS VSUBS VSUBS VSUBS sky130_fd_sc_hd__decap_3
Xsky130_fd_sc_hd__decap_12_380 VSUBS VSUBS VSUBS VSUBS sky130_fd_sc_hd__decap_12
Xsky130_fd_sc_hd__decap_12_391 VSUBS VSUBS VSUBS VSUBS sky130_fd_sc_hd__decap_12
Xsky130_fd_sc_hd__dfxtp_1_9 VSUBS VSUBS VSUBS VSUBS VSUBS VSUBS VSUBS sky130_fd_sc_hd__dfxtp_1_9/a_975_413#
+ VSUBS VSUBS sky130_fd_sc_hd__dfxtp_1_9/a_592_47# VSUBS VSUBS sky130_fd_sc_hd__dfxtp_1_9/a_561_413#
+ VSUBS VSUBS VSUBS sky130_fd_sc_hd__dfxtp_1
Xsky130_fd_sc_hd__mux2i_1_15 VSUBS VSUBS VSUBS VSUBS VSUBS VSUBS VSUBS VSUBS VSUBS
+ VSUBS VSUBS VSUBS sky130_fd_sc_hd__mux2i_1
Xsky130_fd_sc_hd__clkinv_1_13 VSUBS VSUBS VSUBS VSUBS VSUBS VSUBS sky130_fd_sc_hd__clkinv_1
Xsky130_fd_sc_hd__nand4_1_0 VSUBS VSUBS VSUBS VSUBS VSUBS VSUBS VSUBS VSUBS VSUBS
+ sky130_fd_sc_hd__nand4_1
Xsky130_fd_sc_hd__nand2_1_40 VSUBS VSUBS VSUBS VSUBS VSUBS VSUBS VSUBS sky130_fd_sc_hd__nand2_1
Xsky130_fd_sc_hd__decap_4_95 VSUBS VSUBS VSUBS VSUBS sky130_fd_sc_hd__decap_4
Xsky130_fd_sc_hd__decap_4_84 VSUBS VSUBS VSUBS VSUBS sky130_fd_sc_hd__decap_4
Xsky130_fd_sc_hd__decap_4_62 VSUBS VSUBS VSUBS VSUBS sky130_fd_sc_hd__decap_4
Xsky130_fd_sc_hd__decap_4_73 VSUBS VSUBS VSUBS VSUBS sky130_fd_sc_hd__decap_4
Xsky130_fd_sc_hd__decap_4_51 VSUBS VSUBS VSUBS VSUBS sky130_fd_sc_hd__decap_4
Xsky130_fd_sc_hd__decap_4_40 VSUBS VSUBS VSUBS VSUBS sky130_fd_sc_hd__decap_4
Xsky130_fd_sc_hd__decap_8_120 VSUBS VSUBS VSUBS VSUBS sky130_fd_sc_hd__decap_8
Xsky130_fd_sc_hd__decap_8_175 VSUBS VSUBS VSUBS VSUBS sky130_fd_sc_hd__decap_8
Xsky130_fd_sc_hd__decap_8_164 VSUBS VSUBS VSUBS VSUBS sky130_fd_sc_hd__decap_8
Xsky130_fd_sc_hd__decap_8_153 VSUBS VSUBS VSUBS VSUBS sky130_fd_sc_hd__decap_8
Xsky130_fd_sc_hd__decap_8_197 VSUBS VSUBS VSUBS VSUBS sky130_fd_sc_hd__decap_8
Xsky130_fd_sc_hd__decap_8_142 VSUBS VSUBS VSUBS VSUBS sky130_fd_sc_hd__decap_8
Xsky130_fd_sc_hd__decap_8_186 VSUBS VSUBS VSUBS VSUBS sky130_fd_sc_hd__decap_8
Xsky130_fd_sc_hd__decap_8_131 VSUBS VSUBS VSUBS VSUBS sky130_fd_sc_hd__decap_8
Xsky130_fd_sc_hd__a21oi_1_19 VSUBS VSUBS VSUBS VSUBS VSUBS VSUBS VSUBS VSUBS VSUBS
+ sky130_fd_sc_hd__a21oi_1
Xsky130_fd_sc_hd__decap_12_59 VSUBS VSUBS VSUBS VSUBS sky130_fd_sc_hd__decap_12
Xsky130_fd_sc_hd__decap_12_15 VSUBS VSUBS VSUBS VSUBS sky130_fd_sc_hd__decap_12
Xsky130_fd_sc_hd__decap_12_48 VSUBS VSUBS VSUBS VSUBS sky130_fd_sc_hd__decap_12
Xsky130_fd_sc_hd__decap_12_37 VSUBS VSUBS VSUBS VSUBS sky130_fd_sc_hd__decap_12
Xsky130_fd_sc_hd__decap_12_26 VSUBS VSUBS VSUBS VSUBS sky130_fd_sc_hd__decap_12
Xsky130_fd_sc_hd__nor2_1_0 VSUBS VSUBS VSUBS VSUBS VSUBS VSUBS VSUBS sky130_fd_sc_hd__nor2_1
Xsky130_fd_sc_hd__decap_12_913 VSUBS VSUBS VSUBS VSUBS sky130_fd_sc_hd__decap_12
Xsky130_fd_sc_hd__decap_12_957 VSUBS VSUBS VSUBS VSUBS sky130_fd_sc_hd__decap_12
Xsky130_fd_sc_hd__decap_12_924 VSUBS VSUBS VSUBS VSUBS sky130_fd_sc_hd__decap_12
Xsky130_fd_sc_hd__decap_12_968 VSUBS VSUBS VSUBS VSUBS sky130_fd_sc_hd__decap_12
Xsky130_fd_sc_hd__decap_12_902 VSUBS VSUBS VSUBS VSUBS sky130_fd_sc_hd__decap_12
Xsky130_fd_sc_hd__decap_12_979 VSUBS VSUBS VSUBS VSUBS sky130_fd_sc_hd__decap_12
Xsky130_fd_sc_hd__decap_12_935 VSUBS VSUBS VSUBS VSUBS sky130_fd_sc_hd__decap_12
Xsky130_fd_sc_hd__decap_12_946 VSUBS VSUBS VSUBS VSUBS sky130_fd_sc_hd__decap_12
Xsky130_fd_sc_hd__o31a_1_2 VSUBS VSUBS VSUBS VSUBS sky130_fd_sc_hd__o31a_1_2/X VSUBS
+ VSUBS VSUBS VSUBS VSUBS VSUBS sky130_fd_sc_hd__o31a_1
Xsky130_fd_sc_hd__decap_12_209 VSUBS VSUBS VSUBS VSUBS sky130_fd_sc_hd__decap_12
Xsky130_fd_sc_hd__xor2_1_8 VSUBS VSUBS VSUBS VSUBS VSUBS VSUBS VSUBS VSUBS VSUBS sky130_fd_sc_hd__xor2_1
Xsky130_fd_sc_hd__decap_12_754 VSUBS VSUBS VSUBS VSUBS sky130_fd_sc_hd__decap_12
Xsky130_fd_sc_hd__decap_12_798 VSUBS VSUBS VSUBS VSUBS sky130_fd_sc_hd__decap_12
Xsky130_fd_sc_hd__decap_12_743 VSUBS VSUBS VSUBS VSUBS sky130_fd_sc_hd__decap_12
Xsky130_fd_sc_hd__decap_12_765 VSUBS VSUBS VSUBS VSUBS sky130_fd_sc_hd__decap_12
Xsky130_fd_sc_hd__decap_12_776 VSUBS VSUBS VSUBS VSUBS sky130_fd_sc_hd__decap_12
Xsky130_fd_sc_hd__decap_12_721 VSUBS VSUBS VSUBS VSUBS sky130_fd_sc_hd__decap_12
Xsky130_fd_sc_hd__decap_12_710 VSUBS VSUBS VSUBS VSUBS sky130_fd_sc_hd__decap_12
Xsky130_fd_sc_hd__decap_12_787 VSUBS VSUBS VSUBS VSUBS sky130_fd_sc_hd__decap_12
Xsky130_fd_sc_hd__decap_12_732 VSUBS VSUBS VSUBS VSUBS sky130_fd_sc_hd__decap_12
Xsky130_fd_sc_hd__decap_6_19 VSUBS VSUBS VSUBS VSUBS sky130_fd_sc_hd__decap_6
Xsky130_fd_sc_hd__a22oi_1_13 VSUBS VSUBS VSUBS VSUBS VSUBS VSUBS VSUBS VSUBS VSUBS
+ sky130_fd_sc_hd__a22oi_1_13/a_381_47# VSUBS sky130_fd_sc_hd__a22oi_1
Xsky130_fd_sc_hd__decap_12_1016 VSUBS VSUBS VSUBS VSUBS sky130_fd_sc_hd__decap_12
Xsky130_fd_sc_hd__decap_12_1005 VSUBS VSUBS VSUBS VSUBS sky130_fd_sc_hd__decap_12
Xsky130_fd_sc_hd__nor2_1_80 VSUBS VSUBS VSUBS VSUBS VSUBS VSUBS VSUBS sky130_fd_sc_hd__nor2_1
Xsky130_fd_sc_hd__decap_12_1049 VSUBS VSUBS VSUBS VSUBS sky130_fd_sc_hd__decap_12
Xsky130_fd_sc_hd__decap_12_1038 VSUBS VSUBS VSUBS VSUBS sky130_fd_sc_hd__decap_12
Xsky130_fd_sc_hd__decap_12_1027 VSUBS VSUBS VSUBS VSUBS sky130_fd_sc_hd__decap_12
Xsky130_fd_sc_hd__o21a_1_1 VSUBS VSUBS VSUBS VSUBS VSUBS VSUBS VSUBS VSUBS VSUBS VSUBS
+ sky130_fd_sc_hd__o21a_1
Xsky130_fd_sc_hd__decap_12_595 VSUBS VSUBS VSUBS VSUBS sky130_fd_sc_hd__decap_12
Xsky130_fd_sc_hd__decap_12_584 VSUBS VSUBS VSUBS VSUBS sky130_fd_sc_hd__decap_12
Xsky130_fd_sc_hd__decap_12_562 VSUBS VSUBS VSUBS VSUBS sky130_fd_sc_hd__decap_12
Xsky130_fd_sc_hd__decap_12_573 VSUBS VSUBS VSUBS VSUBS sky130_fd_sc_hd__decap_12
Xsky130_fd_sc_hd__decap_12_540 VSUBS VSUBS VSUBS VSUBS sky130_fd_sc_hd__decap_12
Xsky130_fd_sc_hd__decap_12_551 VSUBS VSUBS VSUBS VSUBS sky130_fd_sc_hd__decap_12
Xsky130_fd_sc_hd__xnor2_1_0 VSUBS VSUBS VSUBS VSUBS VSUBS VSUBS VSUBS VSUBS VSUBS
+ sky130_fd_sc_hd__xnor2_1_0/a_377_297# sky130_fd_sc_hd__xnor2_1
Xsky130_fd_sc_hd__dfxtp_1_15 VSUBS VSUBS VSUBS VSUBS VSUBS VSUBS VSUBS sky130_fd_sc_hd__dfxtp_1_15/a_975_413#
+ VSUBS VSUBS sky130_fd_sc_hd__dfxtp_1_15/a_592_47# VSUBS VSUBS sky130_fd_sc_hd__dfxtp_1_15/a_561_413#
+ VSUBS VSUBS VSUBS sky130_fd_sc_hd__dfxtp_1
Xsky130_fd_sc_hd__dfxtp_1_59 VSUBS VSUBS VSUBS VSUBS VSUBS VSUBS VSUBS sky130_fd_sc_hd__dfxtp_1_59/a_975_413#
+ VSUBS VSUBS sky130_fd_sc_hd__dfxtp_1_59/a_592_47# VSUBS VSUBS sky130_fd_sc_hd__dfxtp_1_59/a_561_413#
+ VSUBS VSUBS VSUBS sky130_fd_sc_hd__dfxtp_1
Xsky130_fd_sc_hd__dfxtp_1_48 VSUBS VSUBS VSUBS VSUBS VSUBS VSUBS VSUBS sky130_fd_sc_hd__dfxtp_1_48/a_975_413#
+ VSUBS VSUBS sky130_fd_sc_hd__dfxtp_1_48/a_592_47# VSUBS VSUBS sky130_fd_sc_hd__dfxtp_1_48/a_561_413#
+ VSUBS VSUBS VSUBS sky130_fd_sc_hd__dfxtp_1
Xsky130_fd_sc_hd__dfxtp_1_37 VSUBS VSUBS VSUBS VSUBS VSUBS VSUBS VSUBS sky130_fd_sc_hd__dfxtp_1_37/a_975_413#
+ VSUBS VSUBS sky130_fd_sc_hd__dfxtp_1_37/a_592_47# VSUBS VSUBS sky130_fd_sc_hd__dfxtp_1_37/a_561_413#
+ VSUBS VSUBS VSUBS sky130_fd_sc_hd__dfxtp_1
Xsky130_fd_sc_hd__dfxtp_1_26 VSUBS VSUBS VSUBS VSUBS VSUBS VSUBS VSUBS sky130_fd_sc_hd__dfxtp_1_26/a_975_413#
+ VSUBS VSUBS sky130_fd_sc_hd__dfxtp_1_26/a_592_47# VSUBS VSUBS sky130_fd_sc_hd__dfxtp_1_26/a_561_413#
+ VSUBS VSUBS VSUBS sky130_fd_sc_hd__dfxtp_1
Xsky130_fd_sc_hd__clkbuf_4_0 VSUBS VSUBS VSUBS VSUBS VSUBS VSUBS VSUBS sky130_fd_sc_hd__clkbuf_4
Xsky130_fd_sc_hd__decap_12_370 VSUBS VSUBS VSUBS VSUBS sky130_fd_sc_hd__decap_12
Xsky130_fd_sc_hd__decap_12_381 VSUBS VSUBS VSUBS VSUBS sky130_fd_sc_hd__decap_12
Xsky130_fd_sc_hd__decap_12_392 VSUBS VSUBS VSUBS VSUBS sky130_fd_sc_hd__decap_12
Xsky130_fd_sc_hd__clkinv_1_14 VSUBS VSUBS VSUBS VSUBS VSUBS VSUBS sky130_fd_sc_hd__clkinv_1
Xsky130_fd_sc_hd__nand4_1_1 VSUBS VSUBS VSUBS VSUBS VSUBS VSUBS VSUBS VSUBS VSUBS
+ sky130_fd_sc_hd__nand4_1
Xsky130_fd_sc_hd__nand2_1_41 VSUBS VSUBS VSUBS VSUBS VSUBS VSUBS VSUBS sky130_fd_sc_hd__nand2_1
Xsky130_fd_sc_hd__nand2_1_30 VSUBS VSUBS VSUBS VSUBS VSUBS VSUBS VSUBS sky130_fd_sc_hd__nand2_1
Xsky130_fd_sc_hd__decap_4_63 VSUBS VSUBS VSUBS VSUBS sky130_fd_sc_hd__decap_4
Xsky130_fd_sc_hd__decap_4_96 VSUBS VSUBS VSUBS VSUBS sky130_fd_sc_hd__decap_4
Xsky130_fd_sc_hd__decap_4_85 VSUBS VSUBS VSUBS VSUBS sky130_fd_sc_hd__decap_4
Xsky130_fd_sc_hd__decap_4_74 VSUBS VSUBS VSUBS VSUBS sky130_fd_sc_hd__decap_4
Xsky130_fd_sc_hd__decap_8_143 VSUBS VSUBS VSUBS VSUBS sky130_fd_sc_hd__decap_8
Xsky130_fd_sc_hd__decap_8_132 VSUBS VSUBS VSUBS VSUBS sky130_fd_sc_hd__decap_8
Xsky130_fd_sc_hd__decap_4_52 VSUBS VSUBS VSUBS VSUBS sky130_fd_sc_hd__decap_4
Xsky130_fd_sc_hd__decap_8_121 VSUBS VSUBS VSUBS VSUBS sky130_fd_sc_hd__decap_8
Xsky130_fd_sc_hd__decap_8_110 VSUBS VSUBS VSUBS VSUBS sky130_fd_sc_hd__decap_8
Xsky130_fd_sc_hd__decap_4_30 VSUBS VSUBS VSUBS VSUBS sky130_fd_sc_hd__decap_4
Xsky130_fd_sc_hd__decap_4_41 VSUBS VSUBS VSUBS VSUBS sky130_fd_sc_hd__decap_4
Xsky130_fd_sc_hd__decap_8_176 VSUBS VSUBS VSUBS VSUBS sky130_fd_sc_hd__decap_8
Xsky130_fd_sc_hd__decap_8_165 VSUBS VSUBS VSUBS VSUBS sky130_fd_sc_hd__decap_8
Xsky130_fd_sc_hd__decap_8_198 VSUBS VSUBS VSUBS VSUBS sky130_fd_sc_hd__decap_8
Xsky130_fd_sc_hd__decap_8_154 VSUBS VSUBS VSUBS VSUBS sky130_fd_sc_hd__decap_8
Xsky130_fd_sc_hd__decap_8_187 VSUBS VSUBS VSUBS VSUBS sky130_fd_sc_hd__decap_8
Xsky130_fd_sc_hd__decap_12_38 VSUBS VSUBS VSUBS VSUBS sky130_fd_sc_hd__decap_12
Xsky130_fd_sc_hd__decap_12_49 VSUBS VSUBS VSUBS VSUBS sky130_fd_sc_hd__decap_12
Xsky130_fd_sc_hd__decap_12_16 VSUBS VSUBS VSUBS VSUBS sky130_fd_sc_hd__decap_12
Xsky130_fd_sc_hd__decap_12_27 VSUBS VSUBS VSUBS VSUBS sky130_fd_sc_hd__decap_12
Xsky130_fd_sc_hd__nor2_1_1 VSUBS VSUBS VSUBS VSUBS VSUBS VSUBS VSUBS sky130_fd_sc_hd__nor2_1
Xsky130_fd_sc_hd__inv_6_0 VSUBS VSUBS VSUBS VSUBS VSUBS VSUBS sky130_fd_sc_hd__inv_6
Xsky130_fd_sc_hd__decap_12_925 VSUBS VSUBS VSUBS VSUBS sky130_fd_sc_hd__decap_12
Xsky130_fd_sc_hd__decap_12_958 VSUBS VSUBS VSUBS VSUBS sky130_fd_sc_hd__decap_12
Xsky130_fd_sc_hd__decap_12_914 VSUBS VSUBS VSUBS VSUBS sky130_fd_sc_hd__decap_12
Xsky130_fd_sc_hd__decap_12_969 VSUBS VSUBS VSUBS VSUBS sky130_fd_sc_hd__decap_12
Xsky130_fd_sc_hd__decap_12_903 VSUBS VSUBS VSUBS VSUBS sky130_fd_sc_hd__decap_12
Xsky130_fd_sc_hd__decap_12_936 VSUBS VSUBS VSUBS VSUBS sky130_fd_sc_hd__decap_12
Xsky130_fd_sc_hd__decap_12_947 VSUBS VSUBS VSUBS VSUBS sky130_fd_sc_hd__decap_12
Xsky130_fd_sc_hd__xor2_1_9 VSUBS VSUBS VSUBS VSUBS VSUBS VSUBS VSUBS VSUBS VSUBS sky130_fd_sc_hd__xor2_1
Xsky130_fd_sc_hd__decap_12_700 VSUBS VSUBS VSUBS VSUBS sky130_fd_sc_hd__decap_12
Xsky130_fd_sc_hd__decap_12_711 VSUBS VSUBS VSUBS VSUBS sky130_fd_sc_hd__decap_12
Xsky130_fd_sc_hd__decap_12_777 VSUBS VSUBS VSUBS VSUBS sky130_fd_sc_hd__decap_12
Xsky130_fd_sc_hd__decap_12_766 VSUBS VSUBS VSUBS VSUBS sky130_fd_sc_hd__decap_12
Xsky130_fd_sc_hd__decap_12_755 VSUBS VSUBS VSUBS VSUBS sky130_fd_sc_hd__decap_12
Xsky130_fd_sc_hd__decap_12_788 VSUBS VSUBS VSUBS VSUBS sky130_fd_sc_hd__decap_12
Xsky130_fd_sc_hd__decap_12_744 VSUBS VSUBS VSUBS VSUBS sky130_fd_sc_hd__decap_12
Xsky130_fd_sc_hd__decap_12_799 VSUBS VSUBS VSUBS VSUBS sky130_fd_sc_hd__decap_12
Xsky130_fd_sc_hd__decap_12_722 VSUBS VSUBS VSUBS VSUBS sky130_fd_sc_hd__decap_12
Xsky130_fd_sc_hd__decap_12_733 VSUBS VSUBS VSUBS VSUBS sky130_fd_sc_hd__decap_12
Xsky130_fd_sc_hd__and2_1_0 VSUBS VSUBS VSUBS VSUBS VSUBS VSUBS VSUBS VSUBS sky130_fd_sc_hd__and2_1
Xsky130_fd_sc_hd__nor2_1_70 VSUBS VSUBS VSUBS VSUBS VSUBS VSUBS VSUBS sky130_fd_sc_hd__nor2_1
Xsky130_fd_sc_hd__decap_12_1017 VSUBS VSUBS VSUBS VSUBS sky130_fd_sc_hd__decap_12
Xsky130_fd_sc_hd__decap_12_1006 VSUBS VSUBS VSUBS VSUBS sky130_fd_sc_hd__decap_12
Xsky130_fd_sc_hd__nor2_1_81 VSUBS VSUBS VSUBS VSUBS VSUBS VSUBS VSUBS sky130_fd_sc_hd__nor2_1
Xsky130_fd_sc_hd__decap_12_1039 VSUBS VSUBS VSUBS VSUBS sky130_fd_sc_hd__decap_12
Xsky130_fd_sc_hd__decap_12_1028 VSUBS VSUBS VSUBS VSUBS sky130_fd_sc_hd__decap_12
Xsky130_fd_sc_hd__decap_12_552 VSUBS VSUBS VSUBS VSUBS sky130_fd_sc_hd__decap_12
Xsky130_fd_sc_hd__decap_12_541 VSUBS VSUBS VSUBS VSUBS sky130_fd_sc_hd__decap_12
Xsky130_fd_sc_hd__o21a_1_2 VSUBS VSUBS VSUBS VSUBS VSUBS VSUBS VSUBS VSUBS VSUBS VSUBS
+ sky130_fd_sc_hd__o21a_1
Xsky130_fd_sc_hd__decap_12_530 VSUBS VSUBS VSUBS VSUBS sky130_fd_sc_hd__decap_12
Xsky130_fd_sc_hd__decap_12_585 VSUBS VSUBS VSUBS VSUBS sky130_fd_sc_hd__decap_12
Xsky130_fd_sc_hd__decap_12_596 VSUBS VSUBS VSUBS VSUBS sky130_fd_sc_hd__decap_12
Xsky130_fd_sc_hd__decap_12_574 VSUBS VSUBS VSUBS VSUBS sky130_fd_sc_hd__decap_12
Xsky130_fd_sc_hd__decap_12_563 VSUBS VSUBS VSUBS VSUBS sky130_fd_sc_hd__decap_12
Xsky130_fd_sc_hd__xnor2_1_1 VSUBS VSUBS VSUBS VSUBS VSUBS VSUBS VSUBS VSUBS VSUBS
+ sky130_fd_sc_hd__xnor2_1_1/a_377_297# sky130_fd_sc_hd__xnor2_1
Xsky130_fd_sc_hd__dfxtp_1_49 VSUBS VSUBS VSUBS VSUBS VSUBS VSUBS VSUBS sky130_fd_sc_hd__dfxtp_1_49/a_975_413#
+ VSUBS VSUBS sky130_fd_sc_hd__dfxtp_1_49/a_592_47# VSUBS VSUBS sky130_fd_sc_hd__dfxtp_1_49/a_561_413#
+ VSUBS VSUBS VSUBS sky130_fd_sc_hd__dfxtp_1
Xsky130_fd_sc_hd__dfxtp_1_38 VSUBS VSUBS VSUBS VSUBS VSUBS sky130_fd_sc_hd__dfxtp_1_38/D
+ VSUBS sky130_fd_sc_hd__dfxtp_1_38/a_975_413# VSUBS VSUBS sky130_fd_sc_hd__dfxtp_1_38/a_592_47#
+ VSUBS VSUBS sky130_fd_sc_hd__dfxtp_1_38/a_561_413# VSUBS VSUBS VSUBS sky130_fd_sc_hd__dfxtp_1
Xsky130_fd_sc_hd__dfxtp_1_16 VSUBS VSUBS VSUBS VSUBS VSUBS VSUBS VSUBS sky130_fd_sc_hd__dfxtp_1_16/a_975_413#
+ VSUBS VSUBS sky130_fd_sc_hd__dfxtp_1_16/a_592_47# VSUBS VSUBS sky130_fd_sc_hd__dfxtp_1_16/a_561_413#
+ VSUBS VSUBS VSUBS sky130_fd_sc_hd__dfxtp_1
Xsky130_fd_sc_hd__dfxtp_1_27 VSUBS VSUBS VSUBS VSUBS VSUBS VSUBS VSUBS sky130_fd_sc_hd__dfxtp_1_27/a_975_413#
+ VSUBS VSUBS sky130_fd_sc_hd__dfxtp_1_27/a_592_47# VSUBS VSUBS sky130_fd_sc_hd__dfxtp_1_27/a_561_413#
+ VSUBS VSUBS VSUBS sky130_fd_sc_hd__dfxtp_1
Xsky130_fd_sc_hd__decap_3_200 VSUBS VSUBS VSUBS VSUBS sky130_fd_sc_hd__decap_3
Xsky130_fd_sc_hd__decap_12_371 VSUBS VSUBS VSUBS VSUBS sky130_fd_sc_hd__decap_12
Xsky130_fd_sc_hd__decap_12_360 VSUBS VSUBS VSUBS VSUBS sky130_fd_sc_hd__decap_12
Xsky130_fd_sc_hd__decap_12_393 VSUBS VSUBS VSUBS VSUBS sky130_fd_sc_hd__decap_12
Xsky130_fd_sc_hd__decap_12_382 VSUBS VSUBS VSUBS VSUBS sky130_fd_sc_hd__decap_12
Xsky130_fd_sc_hd__nor4b_1_0 VSUBS VSUBS VSUBS VSUBS VSUBS VSUBS VSUBS VSUBS VSUBS
+ VSUBS sky130_fd_sc_hd__nor4b_1
Xsky130_fd_sc_hd__clkinv_1_15 VSUBS VSUBS VSUBS VSUBS VSUBS VSUBS sky130_fd_sc_hd__clkinv_1
Xsky130_fd_sc_hd__nand4_1_2 VSUBS VSUBS VSUBS VSUBS VSUBS VSUBS VSUBS VSUBS VSUBS
+ sky130_fd_sc_hd__nand4_1
Xsky130_fd_sc_hd__nand2_1_31 VSUBS VSUBS VSUBS VSUBS VSUBS VSUBS VSUBS sky130_fd_sc_hd__nand2_1
Xsky130_fd_sc_hd__nand2_1_42 VSUBS VSUBS VSUBS VSUBS VSUBS VSUBS VSUBS sky130_fd_sc_hd__nand2_1
Xsky130_fd_sc_hd__nand2_1_20 VSUBS VSUBS VSUBS VSUBS VSUBS VSUBS VSUBS sky130_fd_sc_hd__nand2_1
Xsky130_fd_sc_hd__decap_12_190 VSUBS VSUBS VSUBS VSUBS sky130_fd_sc_hd__decap_12
Xsky130_fd_sc_hd__decap_4_20 VSUBS VSUBS VSUBS VSUBS sky130_fd_sc_hd__decap_4
Xsky130_fd_sc_hd__decap_4_42 VSUBS VSUBS VSUBS VSUBS sky130_fd_sc_hd__decap_4
Xsky130_fd_sc_hd__decap_4_31 VSUBS VSUBS VSUBS VSUBS sky130_fd_sc_hd__decap_4
Xsky130_fd_sc_hd__decap_4_64 VSUBS VSUBS VSUBS VSUBS sky130_fd_sc_hd__decap_4
Xsky130_fd_sc_hd__decap_4_97 VSUBS VSUBS VSUBS VSUBS sky130_fd_sc_hd__decap_4
Xsky130_fd_sc_hd__decap_8_177 VSUBS VSUBS VSUBS VSUBS sky130_fd_sc_hd__decap_8
Xsky130_fd_sc_hd__decap_8_155 VSUBS VSUBS VSUBS VSUBS sky130_fd_sc_hd__decap_8
Xsky130_fd_sc_hd__decap_4_86 VSUBS VSUBS VSUBS VSUBS sky130_fd_sc_hd__decap_4
Xsky130_fd_sc_hd__decap_8_166 VSUBS VSUBS VSUBS VSUBS sky130_fd_sc_hd__decap_8
Xsky130_fd_sc_hd__decap_8_144 VSUBS VSUBS VSUBS VSUBS sky130_fd_sc_hd__decap_8
Xsky130_fd_sc_hd__decap_4_75 VSUBS VSUBS VSUBS VSUBS sky130_fd_sc_hd__decap_4
Xsky130_fd_sc_hd__decap_8_133 VSUBS VSUBS VSUBS VSUBS sky130_fd_sc_hd__decap_8
Xsky130_fd_sc_hd__decap_8_100 VSUBS VSUBS VSUBS VSUBS sky130_fd_sc_hd__decap_8
Xsky130_fd_sc_hd__decap_4_53 VSUBS VSUBS VSUBS VSUBS sky130_fd_sc_hd__decap_4
Xsky130_fd_sc_hd__decap_8_111 VSUBS VSUBS VSUBS VSUBS sky130_fd_sc_hd__decap_8
Xsky130_fd_sc_hd__decap_8_122 VSUBS VSUBS VSUBS VSUBS sky130_fd_sc_hd__decap_8
Xsky130_fd_sc_hd__decap_8_199 VSUBS VSUBS VSUBS VSUBS sky130_fd_sc_hd__decap_8
Xsky130_fd_sc_hd__decap_8_188 VSUBS VSUBS VSUBS VSUBS sky130_fd_sc_hd__decap_8
Xsky130_fd_sc_hd__decap_12_17 VSUBS VSUBS VSUBS VSUBS sky130_fd_sc_hd__decap_12
Xsky130_fd_sc_hd__decap_12_39 VSUBS VSUBS VSUBS VSUBS sky130_fd_sc_hd__decap_12
Xsky130_fd_sc_hd__decap_12_28 VSUBS VSUBS VSUBS VSUBS sky130_fd_sc_hd__decap_12
Xsky130_fd_sc_hd__nor2_1_2 VSUBS VSUBS VSUBS VSUBS VSUBS VSUBS VSUBS sky130_fd_sc_hd__nor2_1
Xsky130_fd_sc_hd__inv_6_1 VSUBS VSUBS VSUBS VSUBS VSUBS VSUBS sky130_fd_sc_hd__inv_6
Xsky130_fd_sc_hd__decap_12_959 VSUBS VSUBS VSUBS VSUBS sky130_fd_sc_hd__decap_12
Xsky130_fd_sc_hd__decap_12_915 VSUBS VSUBS VSUBS VSUBS sky130_fd_sc_hd__decap_12
Xsky130_fd_sc_hd__decap_12_926 VSUBS VSUBS VSUBS VSUBS sky130_fd_sc_hd__decap_12
Xsky130_fd_sc_hd__decap_12_948 VSUBS VSUBS VSUBS VSUBS sky130_fd_sc_hd__decap_12
Xsky130_fd_sc_hd__decap_12_904 VSUBS VSUBS VSUBS VSUBS sky130_fd_sc_hd__decap_12
Xsky130_fd_sc_hd__decap_12_937 VSUBS VSUBS VSUBS VSUBS sky130_fd_sc_hd__decap_12
Xsky130_fd_sc_hd__decap_12_712 VSUBS VSUBS VSUBS VSUBS sky130_fd_sc_hd__decap_12
Xsky130_fd_sc_hd__decap_12_701 VSUBS VSUBS VSUBS VSUBS sky130_fd_sc_hd__decap_12
Xsky130_fd_sc_hd__decap_12_723 VSUBS VSUBS VSUBS VSUBS sky130_fd_sc_hd__decap_12
Xsky130_fd_sc_hd__decap_12_734 VSUBS VSUBS VSUBS VSUBS sky130_fd_sc_hd__decap_12
Xsky130_fd_sc_hd__decap_12_778 VSUBS VSUBS VSUBS VSUBS sky130_fd_sc_hd__decap_12
Xsky130_fd_sc_hd__decap_12_756 VSUBS VSUBS VSUBS VSUBS sky130_fd_sc_hd__decap_12
Xsky130_fd_sc_hd__decap_12_789 VSUBS VSUBS VSUBS VSUBS sky130_fd_sc_hd__decap_12
Xsky130_fd_sc_hd__decap_12_767 VSUBS VSUBS VSUBS VSUBS sky130_fd_sc_hd__decap_12
Xsky130_fd_sc_hd__decap_12_745 VSUBS VSUBS VSUBS VSUBS sky130_fd_sc_hd__decap_12
Xsky130_fd_sc_hd__nor2_1_82 VSUBS VSUBS VSUBS VSUBS VSUBS VSUBS VSUBS sky130_fd_sc_hd__nor2_1
Xsky130_fd_sc_hd__nor2_1_71 VSUBS VSUBS VSUBS VSUBS VSUBS VSUBS VSUBS sky130_fd_sc_hd__nor2_1
Xsky130_fd_sc_hd__nor2_1_60 VSUBS VSUBS VSUBS VSUBS VSUBS VSUBS VSUBS sky130_fd_sc_hd__nor2_1
Xsky130_fd_sc_hd__decap_12_1018 VSUBS VSUBS VSUBS VSUBS sky130_fd_sc_hd__decap_12
Xsky130_fd_sc_hd__decap_12_1007 VSUBS VSUBS VSUBS VSUBS sky130_fd_sc_hd__decap_12
Xsky130_fd_sc_hd__decap_12_1029 VSUBS VSUBS VSUBS VSUBS sky130_fd_sc_hd__decap_12
Xsky130_fd_sc_hd__decap_12_586 VSUBS VSUBS VSUBS VSUBS sky130_fd_sc_hd__decap_12
Xsky130_fd_sc_hd__decap_12_575 VSUBS VSUBS VSUBS VSUBS sky130_fd_sc_hd__decap_12
Xsky130_fd_sc_hd__decap_12_564 VSUBS VSUBS VSUBS VSUBS sky130_fd_sc_hd__decap_12
Xsky130_fd_sc_hd__o21a_1_3 VSUBS VSUBS VSUBS VSUBS VSUBS VSUBS VSUBS VSUBS VSUBS VSUBS
+ sky130_fd_sc_hd__o21a_1
Xsky130_fd_sc_hd__decap_12_531 VSUBS VSUBS VSUBS VSUBS sky130_fd_sc_hd__decap_12
Xsky130_fd_sc_hd__decap_12_553 VSUBS VSUBS VSUBS VSUBS sky130_fd_sc_hd__decap_12
Xsky130_fd_sc_hd__decap_12_542 VSUBS VSUBS VSUBS VSUBS sky130_fd_sc_hd__decap_12
Xsky130_fd_sc_hd__decap_12_520 VSUBS VSUBS VSUBS VSUBS sky130_fd_sc_hd__decap_12
Xsky130_fd_sc_hd__decap_12_597 VSUBS VSUBS VSUBS VSUBS sky130_fd_sc_hd__decap_12
Xsky130_fd_sc_hd__xnor2_1_2 VSUBS VSUBS VSUBS VSUBS VSUBS VSUBS VSUBS VSUBS VSUBS
+ sky130_fd_sc_hd__xnor2_1_2/a_377_297# sky130_fd_sc_hd__xnor2_1
Xsky130_fd_sc_hd__dfxtp_1_39 VSUBS VSUBS VSUBS VSUBS VSUBS VSUBS VSUBS sky130_fd_sc_hd__dfxtp_1_39/a_975_413#
+ VSUBS VSUBS sky130_fd_sc_hd__dfxtp_1_39/a_592_47# VSUBS VSUBS sky130_fd_sc_hd__dfxtp_1_39/a_561_413#
+ VSUBS VSUBS VSUBS sky130_fd_sc_hd__dfxtp_1
Xsky130_fd_sc_hd__dfxtp_1_17 VSUBS VSUBS VSUBS VSUBS VSUBS VSUBS VSUBS sky130_fd_sc_hd__dfxtp_1_17/a_975_413#
+ VSUBS VSUBS sky130_fd_sc_hd__dfxtp_1_17/a_592_47# VSUBS VSUBS sky130_fd_sc_hd__dfxtp_1_17/a_561_413#
+ VSUBS VSUBS VSUBS sky130_fd_sc_hd__dfxtp_1
Xsky130_fd_sc_hd__dfxtp_1_28 VSUBS VSUBS VSUBS VSUBS VSUBS VSUBS VSUBS sky130_fd_sc_hd__dfxtp_1_28/a_975_413#
+ VSUBS VSUBS sky130_fd_sc_hd__dfxtp_1_28/a_592_47# VSUBS VSUBS sky130_fd_sc_hd__dfxtp_1_28/a_561_413#
+ VSUBS VSUBS VSUBS sky130_fd_sc_hd__dfxtp_1
Xsky130_fd_sc_hd__decap_3_201 VSUBS VSUBS VSUBS VSUBS sky130_fd_sc_hd__decap_3
Xsky130_fd_sc_hd__nor4b_1_1 VSUBS VSUBS VSUBS VSUBS VSUBS VSUBS VSUBS VSUBS VSUBS
+ VSUBS sky130_fd_sc_hd__nor4b_1
Xsky130_fd_sc_hd__decap_12_372 VSUBS VSUBS VSUBS VSUBS sky130_fd_sc_hd__decap_12
Xsky130_fd_sc_hd__decap_12_350 VSUBS VSUBS VSUBS VSUBS sky130_fd_sc_hd__decap_12
Xsky130_fd_sc_hd__decap_12_361 VSUBS VSUBS VSUBS VSUBS sky130_fd_sc_hd__decap_12
Xsky130_fd_sc_hd__decap_12_383 VSUBS VSUBS VSUBS VSUBS sky130_fd_sc_hd__decap_12
Xsky130_fd_sc_hd__decap_12_394 VSUBS VSUBS VSUBS VSUBS sky130_fd_sc_hd__decap_12
Xsky130_fd_sc_hd__clkinv_1_16 VSUBS VSUBS VSUBS VSUBS VSUBS VSUBS sky130_fd_sc_hd__clkinv_1
Xsky130_fd_sc_hd__nand2_1_32 VSUBS VSUBS VSUBS VSUBS VSUBS VSUBS sky130_fd_sc_hd__nand2_1_32/B
+ sky130_fd_sc_hd__nand2_1
Xsky130_fd_sc_hd__nand2_1_21 VSUBS VSUBS VSUBS VSUBS VSUBS VSUBS VSUBS sky130_fd_sc_hd__nand2_1
Xsky130_fd_sc_hd__nand2_1_10 VSUBS VSUBS VSUBS VSUBS VSUBS VSUBS VSUBS sky130_fd_sc_hd__nand2_1
Xsky130_fd_sc_hd__decap_12_180 VSUBS VSUBS VSUBS VSUBS sky130_fd_sc_hd__decap_12
Xsky130_fd_sc_hd__decap_12_191 VSUBS VSUBS VSUBS VSUBS sky130_fd_sc_hd__decap_12
Xsky130_fd_sc_hd__decap_4_65 VSUBS VSUBS VSUBS VSUBS sky130_fd_sc_hd__decap_4
Xsky130_fd_sc_hd__decap_4_21 VSUBS VSUBS VSUBS VSUBS sky130_fd_sc_hd__decap_4
Xsky130_fd_sc_hd__decap_4_10 VSUBS VSUBS VSUBS VSUBS sky130_fd_sc_hd__decap_4
Xsky130_fd_sc_hd__decap_4_54 VSUBS VSUBS VSUBS VSUBS sky130_fd_sc_hd__decap_4
Xsky130_fd_sc_hd__decap_4_43 VSUBS VSUBS VSUBS VSUBS sky130_fd_sc_hd__decap_4
Xsky130_fd_sc_hd__decap_4_32 VSUBS VSUBS VSUBS VSUBS sky130_fd_sc_hd__decap_4
Xsky130_fd_sc_hd__decap_4_98 VSUBS VSUBS VSUBS VSUBS sky130_fd_sc_hd__decap_4
Xsky130_fd_sc_hd__decap_4_87 VSUBS VSUBS VSUBS VSUBS sky130_fd_sc_hd__decap_4
Xsky130_fd_sc_hd__decap_8_178 VSUBS VSUBS VSUBS VSUBS sky130_fd_sc_hd__decap_8
Xsky130_fd_sc_hd__decap_8_156 VSUBS VSUBS VSUBS VSUBS sky130_fd_sc_hd__decap_8
Xsky130_fd_sc_hd__decap_8_167 VSUBS VSUBS VSUBS VSUBS sky130_fd_sc_hd__decap_8
Xsky130_fd_sc_hd__decap_4_76 VSUBS VSUBS VSUBS VSUBS sky130_fd_sc_hd__decap_4
Xsky130_fd_sc_hd__decap_8_145 VSUBS VSUBS VSUBS VSUBS sky130_fd_sc_hd__decap_8
Xsky130_fd_sc_hd__decap_8_189 VSUBS VSUBS VSUBS VSUBS sky130_fd_sc_hd__decap_8
Xsky130_fd_sc_hd__decap_8_134 VSUBS VSUBS VSUBS VSUBS sky130_fd_sc_hd__decap_8
Xsky130_fd_sc_hd__decap_8_101 VSUBS VSUBS VSUBS VSUBS sky130_fd_sc_hd__decap_8
Xsky130_fd_sc_hd__decap_8_112 VSUBS VSUBS VSUBS VSUBS sky130_fd_sc_hd__decap_8
Xsky130_fd_sc_hd__decap_8_123 VSUBS VSUBS VSUBS VSUBS sky130_fd_sc_hd__decap_8
Xsky130_fd_sc_hd__decap_12_18 VSUBS VSUBS VSUBS VSUBS sky130_fd_sc_hd__decap_12
Xsky130_fd_sc_hd__decap_12_29 VSUBS VSUBS VSUBS VSUBS sky130_fd_sc_hd__decap_12
Xsky130_fd_sc_hd__nor2_1_3 VSUBS VSUBS VSUBS VSUBS VSUBS VSUBS VSUBS sky130_fd_sc_hd__nor2_1
Xsky130_fd_sc_hd__inv_6_2 VSUBS VSUBS VSUBS VSUBS VSUBS VSUBS sky130_fd_sc_hd__inv_6
Xsky130_fd_sc_hd__decap_3_0 VSUBS VSUBS VSUBS VSUBS sky130_fd_sc_hd__decap_3
Xsky130_fd_sc_hd__decap_12_927 VSUBS VSUBS VSUBS VSUBS sky130_fd_sc_hd__decap_12
Xsky130_fd_sc_hd__decap_12_916 VSUBS VSUBS VSUBS VSUBS sky130_fd_sc_hd__decap_12
Xsky130_fd_sc_hd__decap_12_905 VSUBS VSUBS VSUBS VSUBS sky130_fd_sc_hd__decap_12
Xsky130_fd_sc_hd__decap_12_938 VSUBS VSUBS VSUBS VSUBS sky130_fd_sc_hd__decap_12
Xsky130_fd_sc_hd__decap_12_949 VSUBS VSUBS VSUBS VSUBS sky130_fd_sc_hd__decap_12
Xsky130_fd_sc_hd__decap_12_757 VSUBS VSUBS VSUBS VSUBS sky130_fd_sc_hd__decap_12
Xsky130_fd_sc_hd__decap_12_746 VSUBS VSUBS VSUBS VSUBS sky130_fd_sc_hd__decap_12
Xsky130_fd_sc_hd__decap_12_768 VSUBS VSUBS VSUBS VSUBS sky130_fd_sc_hd__decap_12
Xsky130_fd_sc_hd__decap_12_713 VSUBS VSUBS VSUBS VSUBS sky130_fd_sc_hd__decap_12
Xsky130_fd_sc_hd__decap_12_735 VSUBS VSUBS VSUBS VSUBS sky130_fd_sc_hd__decap_12
Xsky130_fd_sc_hd__decap_12_724 VSUBS VSUBS VSUBS VSUBS sky130_fd_sc_hd__decap_12
Xsky130_fd_sc_hd__decap_12_702 VSUBS VSUBS VSUBS VSUBS sky130_fd_sc_hd__decap_12
Xsky130_fd_sc_hd__decap_12_779 VSUBS VSUBS VSUBS VSUBS sky130_fd_sc_hd__decap_12
Xsky130_fd_sc_hd__decap_12_1008 VSUBS VSUBS VSUBS VSUBS sky130_fd_sc_hd__decap_12
Xsky130_fd_sc_hd__nor2_1_72 VSUBS VSUBS VSUBS VSUBS VSUBS VSUBS VSUBS sky130_fd_sc_hd__nor2_1
Xsky130_fd_sc_hd__nor2_1_61 VSUBS VSUBS VSUBS VSUBS VSUBS VSUBS VSUBS sky130_fd_sc_hd__nor2_1
Xsky130_fd_sc_hd__nor2_1_50 VSUBS VSUBS VSUBS VSUBS VSUBS VSUBS VSUBS sky130_fd_sc_hd__nor2_1
Xsky130_fd_sc_hd__nor2_1_83 VSUBS VSUBS VSUBS VSUBS VSUBS VSUBS VSUBS sky130_fd_sc_hd__nor2_1
Xsky130_fd_sc_hd__decap_12_1019 VSUBS VSUBS VSUBS VSUBS sky130_fd_sc_hd__decap_12
Xsky130_fd_sc_hd__decap_12_587 VSUBS VSUBS VSUBS VSUBS sky130_fd_sc_hd__decap_12
Xsky130_fd_sc_hd__decap_12_576 VSUBS VSUBS VSUBS VSUBS sky130_fd_sc_hd__decap_12
Xsky130_fd_sc_hd__decap_12_598 VSUBS VSUBS VSUBS VSUBS sky130_fd_sc_hd__decap_12
Xsky130_fd_sc_hd__decap_12_565 VSUBS VSUBS VSUBS VSUBS sky130_fd_sc_hd__decap_12
Xsky130_fd_sc_hd__decap_12_554 VSUBS VSUBS VSUBS VSUBS sky130_fd_sc_hd__decap_12
Xsky130_fd_sc_hd__decap_12_532 VSUBS VSUBS VSUBS VSUBS sky130_fd_sc_hd__decap_12
Xsky130_fd_sc_hd__decap_12_543 VSUBS VSUBS VSUBS VSUBS sky130_fd_sc_hd__decap_12
Xsky130_fd_sc_hd__decap_12_521 VSUBS VSUBS VSUBS VSUBS sky130_fd_sc_hd__decap_12
Xsky130_fd_sc_hd__decap_12_510 VSUBS VSUBS VSUBS VSUBS sky130_fd_sc_hd__decap_12
Xsky130_fd_sc_hd__xnor2_1_3 VSUBS VSUBS VSUBS VSUBS VSUBS VSUBS VSUBS VSUBS VSUBS
+ sky130_fd_sc_hd__xnor2_1_3/a_377_297# sky130_fd_sc_hd__xnor2_1
Xsky130_fd_sc_hd__dfxtp_1_18 VSUBS VSUBS VSUBS VSUBS VSUBS VSUBS VSUBS VSUBS VSUBS
+ VSUBS sky130_fd_sc_hd__dfxtp_1_18/a_592_47# VSUBS VSUBS sky130_fd_sc_hd__dfxtp_1_18/a_561_413#
+ VSUBS VSUBS VSUBS sky130_fd_sc_hd__dfxtp_1
Xsky130_fd_sc_hd__dfxtp_1_29 VSUBS VSUBS VSUBS VSUBS VSUBS VSUBS VSUBS sky130_fd_sc_hd__dfxtp_1_29/a_975_413#
+ VSUBS VSUBS sky130_fd_sc_hd__dfxtp_1_29/a_592_47# VSUBS VSUBS sky130_fd_sc_hd__dfxtp_1_29/a_561_413#
+ VSUBS VSUBS VSUBS sky130_fd_sc_hd__dfxtp_1
Xsky130_fd_sc_hd__decap_3_202 VSUBS VSUBS VSUBS VSUBS sky130_fd_sc_hd__decap_3
Xsky130_fd_sc_hd__nor4b_1_2 VSUBS VSUBS VSUBS VSUBS VSUBS VSUBS VSUBS VSUBS VSUBS
+ VSUBS sky130_fd_sc_hd__nor4b_1
Xsky130_fd_sc_hd__decap_12_373 VSUBS VSUBS VSUBS VSUBS sky130_fd_sc_hd__decap_12
Xsky130_fd_sc_hd__decap_12_362 VSUBS VSUBS VSUBS VSUBS sky130_fd_sc_hd__decap_12
Xsky130_fd_sc_hd__decap_12_351 VSUBS VSUBS VSUBS VSUBS sky130_fd_sc_hd__decap_12
Xsky130_fd_sc_hd__decap_12_340 VSUBS VSUBS VSUBS VSUBS sky130_fd_sc_hd__decap_12
Xsky130_fd_sc_hd__decap_12_384 VSUBS VSUBS VSUBS VSUBS sky130_fd_sc_hd__decap_12
Xsky130_fd_sc_hd__decap_12_395 VSUBS VSUBS VSUBS VSUBS sky130_fd_sc_hd__decap_12
Xsky130_fd_sc_hd__clkinv_1_17 VSUBS VSUBS VSUBS VSUBS VSUBS VSUBS sky130_fd_sc_hd__clkinv_1
Xsky130_fd_sc_hd__decap_12_170 VSUBS VSUBS VSUBS VSUBS sky130_fd_sc_hd__decap_12
Xsky130_fd_sc_hd__nand2_1_33 VSUBS VSUBS VSUBS VSUBS VSUBS VSUBS VSUBS sky130_fd_sc_hd__nand2_1
Xsky130_fd_sc_hd__nand2_1_22 VSUBS VSUBS VSUBS VSUBS VSUBS VSUBS sky130_fd_sc_hd__nand2_1_22/B
+ sky130_fd_sc_hd__nand2_1
Xsky130_fd_sc_hd__decap_12_181 VSUBS VSUBS VSUBS VSUBS sky130_fd_sc_hd__decap_12
Xsky130_fd_sc_hd__decap_12_192 VSUBS VSUBS VSUBS VSUBS sky130_fd_sc_hd__decap_12
Xsky130_fd_sc_hd__nand2_1_11 VSUBS VSUBS VSUBS VSUBS VSUBS VSUBS VSUBS sky130_fd_sc_hd__nand2_1
Xsky130_fd_sc_hd__decap_4_99 VSUBS VSUBS VSUBS VSUBS sky130_fd_sc_hd__decap_4
Xsky130_fd_sc_hd__decap_4_88 VSUBS VSUBS VSUBS VSUBS sky130_fd_sc_hd__decap_4
Xsky130_fd_sc_hd__decap_4_66 VSUBS VSUBS VSUBS VSUBS sky130_fd_sc_hd__decap_4
Xsky130_fd_sc_hd__decap_4_77 VSUBS VSUBS VSUBS VSUBS sky130_fd_sc_hd__decap_4
Xsky130_fd_sc_hd__decap_4_11 VSUBS VSUBS VSUBS VSUBS sky130_fd_sc_hd__decap_4
Xsky130_fd_sc_hd__decap_4_55 VSUBS VSUBS VSUBS VSUBS sky130_fd_sc_hd__decap_4
Xsky130_fd_sc_hd__decap_4_22 VSUBS VSUBS VSUBS VSUBS sky130_fd_sc_hd__decap_4
Xsky130_fd_sc_hd__decap_4_44 VSUBS VSUBS VSUBS VSUBS sky130_fd_sc_hd__decap_4
Xsky130_fd_sc_hd__decap_4_33 VSUBS VSUBS VSUBS VSUBS sky130_fd_sc_hd__decap_4
Xsky130_fd_sc_hd__decap_8_179 VSUBS VSUBS VSUBS VSUBS sky130_fd_sc_hd__decap_8
Xsky130_fd_sc_hd__decap_8_168 VSUBS VSUBS VSUBS VSUBS sky130_fd_sc_hd__decap_8
Xsky130_fd_sc_hd__decap_8_157 VSUBS VSUBS VSUBS VSUBS sky130_fd_sc_hd__decap_8
Xsky130_fd_sc_hd__decap_8_146 VSUBS VSUBS VSUBS VSUBS sky130_fd_sc_hd__decap_8
Xsky130_fd_sc_hd__decap_8_135 VSUBS VSUBS VSUBS VSUBS sky130_fd_sc_hd__decap_8
Xsky130_fd_sc_hd__decap_8_102 VSUBS VSUBS VSUBS VSUBS sky130_fd_sc_hd__decap_8
Xsky130_fd_sc_hd__decap_8_113 VSUBS VSUBS VSUBS VSUBS sky130_fd_sc_hd__decap_8
Xsky130_fd_sc_hd__decap_8_124 VSUBS VSUBS VSUBS VSUBS sky130_fd_sc_hd__decap_8
Xsky130_fd_sc_hd__decap_12_19 VSUBS VSUBS VSUBS VSUBS sky130_fd_sc_hd__decap_12
Xsky130_fd_sc_hd__inv_6_3 VSUBS VSUBS VSUBS VSUBS VSUBS VSUBS sky130_fd_sc_hd__inv_6
Xsky130_fd_sc_hd__nor2_1_4 VSUBS VSUBS VSUBS VSUBS VSUBS VSUBS VSUBS sky130_fd_sc_hd__nor2_1
Xsky130_fd_sc_hd__decap_3_1 VSUBS VSUBS VSUBS VSUBS sky130_fd_sc_hd__decap_3
Xsky130_fd_sc_hd__decap_12_917 VSUBS VSUBS VSUBS VSUBS sky130_fd_sc_hd__decap_12
Xsky130_fd_sc_hd__decap_12_928 VSUBS VSUBS VSUBS VSUBS sky130_fd_sc_hd__decap_12
Xsky130_fd_sc_hd__decap_12_939 VSUBS VSUBS VSUBS VSUBS sky130_fd_sc_hd__decap_12
Xsky130_fd_sc_hd__decap_12_906 VSUBS VSUBS VSUBS VSUBS sky130_fd_sc_hd__decap_12
Xsky130_fd_sc_hd__decap_12_769 VSUBS VSUBS VSUBS VSUBS sky130_fd_sc_hd__decap_12
Xsky130_fd_sc_hd__decap_12_747 VSUBS VSUBS VSUBS VSUBS sky130_fd_sc_hd__decap_12
Xsky130_fd_sc_hd__decap_12_758 VSUBS VSUBS VSUBS VSUBS sky130_fd_sc_hd__decap_12
Xsky130_fd_sc_hd__decap_12_736 VSUBS VSUBS VSUBS VSUBS sky130_fd_sc_hd__decap_12
Xsky130_fd_sc_hd__decap_12_725 VSUBS VSUBS VSUBS VSUBS sky130_fd_sc_hd__decap_12
Xsky130_fd_sc_hd__decap_12_703 VSUBS VSUBS VSUBS VSUBS sky130_fd_sc_hd__decap_12
Xsky130_fd_sc_hd__decap_12_714 VSUBS VSUBS VSUBS VSUBS sky130_fd_sc_hd__decap_12
Xsky130_fd_sc_hd__nor2_1_73 VSUBS VSUBS VSUBS VSUBS VSUBS VSUBS VSUBS sky130_fd_sc_hd__nor2_1
Xsky130_fd_sc_hd__decap_12_1009 VSUBS VSUBS VSUBS VSUBS sky130_fd_sc_hd__decap_12
Xsky130_fd_sc_hd__nor2_1_62 VSUBS VSUBS VSUBS VSUBS VSUBS VSUBS VSUBS sky130_fd_sc_hd__nor2_1
Xsky130_fd_sc_hd__nor2_1_40 VSUBS VSUBS VSUBS VSUBS VSUBS VSUBS VSUBS sky130_fd_sc_hd__nor2_1
Xsky130_fd_sc_hd__nor2_1_51 VSUBS VSUBS VSUBS VSUBS VSUBS VSUBS VSUBS sky130_fd_sc_hd__nor2_1
Xsky130_fd_sc_hd__nor2_1_84 VSUBS VSUBS VSUBS VSUBS VSUBS VSUBS VSUBS sky130_fd_sc_hd__nor2_1
Xsky130_fd_sc_hd__decap_12_500 VSUBS VSUBS VSUBS VSUBS sky130_fd_sc_hd__decap_12
Xsky130_fd_sc_hd__decap_12_577 VSUBS VSUBS VSUBS VSUBS sky130_fd_sc_hd__decap_12
Xsky130_fd_sc_hd__decap_12_588 VSUBS VSUBS VSUBS VSUBS sky130_fd_sc_hd__decap_12
Xsky130_fd_sc_hd__decap_12_599 VSUBS VSUBS VSUBS VSUBS sky130_fd_sc_hd__decap_12
Xsky130_fd_sc_hd__decap_12_555 VSUBS VSUBS VSUBS VSUBS sky130_fd_sc_hd__decap_12
Xsky130_fd_sc_hd__decap_12_566 VSUBS VSUBS VSUBS VSUBS sky130_fd_sc_hd__decap_12
Xsky130_fd_sc_hd__decap_12_544 VSUBS VSUBS VSUBS VSUBS sky130_fd_sc_hd__decap_12
Xsky130_fd_sc_hd__decap_12_533 VSUBS VSUBS VSUBS VSUBS sky130_fd_sc_hd__decap_12
Xsky130_fd_sc_hd__decap_12_522 VSUBS VSUBS VSUBS VSUBS sky130_fd_sc_hd__decap_12
Xsky130_fd_sc_hd__decap_12_511 VSUBS VSUBS VSUBS VSUBS sky130_fd_sc_hd__decap_12
Xsky130_fd_sc_hd__xnor2_1_4 VSUBS VSUBS VSUBS VSUBS VSUBS VSUBS VSUBS VSUBS VSUBS
+ sky130_fd_sc_hd__xnor2_1_4/a_377_297# sky130_fd_sc_hd__xnor2_1
Xsky130_fd_sc_hd__dfxtp_1_19 VSUBS VSUBS VSUBS VSUBS VSUBS VSUBS VSUBS sky130_fd_sc_hd__dfxtp_1_19/a_975_413#
+ VSUBS VSUBS sky130_fd_sc_hd__dfxtp_1_19/a_592_47# VSUBS VSUBS sky130_fd_sc_hd__dfxtp_1_19/a_561_413#
+ VSUBS VSUBS VSUBS sky130_fd_sc_hd__dfxtp_1
Xsky130_fd_sc_hd__decap_3_203 VSUBS VSUBS VSUBS VSUBS sky130_fd_sc_hd__decap_3
Xsky130_fd_sc_hd__decap_12_330 VSUBS VSUBS VSUBS VSUBS sky130_fd_sc_hd__decap_12
Xsky130_fd_sc_hd__decap_12_352 VSUBS VSUBS VSUBS VSUBS sky130_fd_sc_hd__decap_12
Xsky130_fd_sc_hd__decap_12_341 VSUBS VSUBS VSUBS VSUBS sky130_fd_sc_hd__decap_12
Xsky130_fd_sc_hd__decap_12_374 VSUBS VSUBS VSUBS VSUBS sky130_fd_sc_hd__decap_12
Xsky130_fd_sc_hd__decap_12_363 VSUBS VSUBS VSUBS VSUBS sky130_fd_sc_hd__decap_12
Xsky130_fd_sc_hd__decap_12_385 VSUBS VSUBS VSUBS VSUBS sky130_fd_sc_hd__decap_12
Xsky130_fd_sc_hd__decap_12_396 VSUBS VSUBS VSUBS VSUBS sky130_fd_sc_hd__decap_12
Xsky130_fd_sc_hd__clkinv_1_18 VSUBS VSUBS VSUBS VSUBS VSUBS VSUBS sky130_fd_sc_hd__clkinv_1
Xsky130_fd_sc_hd__decap_12_193 VSUBS VSUBS VSUBS VSUBS sky130_fd_sc_hd__decap_12
Xsky130_fd_sc_hd__decap_12_160 VSUBS VSUBS VSUBS VSUBS sky130_fd_sc_hd__decap_12
Xsky130_fd_sc_hd__nand2_1_23 VSUBS VSUBS VSUBS VSUBS VSUBS VSUBS VSUBS sky130_fd_sc_hd__nand2_1
Xsky130_fd_sc_hd__nand2_1_12 VSUBS VSUBS VSUBS VSUBS VSUBS VSUBS VSUBS sky130_fd_sc_hd__nand2_1
Xsky130_fd_sc_hd__decap_12_171 VSUBS VSUBS VSUBS VSUBS sky130_fd_sc_hd__decap_12
Xsky130_fd_sc_hd__decap_12_182 VSUBS VSUBS VSUBS VSUBS sky130_fd_sc_hd__decap_12
Xsky130_fd_sc_hd__nand2_1_34 VSUBS VSUBS VSUBS VSUBS VSUBS VSUBS VSUBS sky130_fd_sc_hd__nand2_1
Xsky130_fd_sc_hd__decap_4_67 VSUBS VSUBS VSUBS VSUBS sky130_fd_sc_hd__decap_4
Xsky130_fd_sc_hd__decap_4_89 VSUBS VSUBS VSUBS VSUBS sky130_fd_sc_hd__decap_4
Xsky130_fd_sc_hd__decap_4_78 VSUBS VSUBS VSUBS VSUBS sky130_fd_sc_hd__decap_4
Xsky130_fd_sc_hd__decap_8_103 VSUBS VSUBS VSUBS VSUBS sky130_fd_sc_hd__decap_8
Xsky130_fd_sc_hd__decap_4_12 VSUBS VSUBS VSUBS VSUBS sky130_fd_sc_hd__decap_4
Xsky130_fd_sc_hd__decap_4_23 VSUBS VSUBS VSUBS VSUBS sky130_fd_sc_hd__decap_4
Xsky130_fd_sc_hd__decap_4_56 VSUBS VSUBS VSUBS VSUBS sky130_fd_sc_hd__decap_4
Xsky130_fd_sc_hd__decap_8_114 VSUBS VSUBS VSUBS VSUBS sky130_fd_sc_hd__decap_8
Xsky130_fd_sc_hd__decap_4_34 VSUBS VSUBS VSUBS VSUBS sky130_fd_sc_hd__decap_4
Xsky130_fd_sc_hd__decap_4_45 VSUBS VSUBS VSUBS VSUBS sky130_fd_sc_hd__decap_4
Xsky130_fd_sc_hd__decap_8_125 VSUBS VSUBS VSUBS VSUBS sky130_fd_sc_hd__decap_8
Xsky130_fd_sc_hd__decap_8_158 VSUBS VSUBS VSUBS VSUBS sky130_fd_sc_hd__decap_8
Xsky130_fd_sc_hd__decap_8_169 VSUBS VSUBS VSUBS VSUBS sky130_fd_sc_hd__decap_8
Xsky130_fd_sc_hd__decap_8_136 VSUBS VSUBS VSUBS VSUBS sky130_fd_sc_hd__decap_8
Xsky130_fd_sc_hd__decap_8_147 VSUBS VSUBS VSUBS VSUBS sky130_fd_sc_hd__decap_8
Xsky130_fd_sc_hd__inv_6_4 VSUBS VSUBS VSUBS VSUBS VSUBS VSUBS sky130_fd_sc_hd__inv_6
Xsky130_fd_sc_hd__nor2_1_5 VSUBS VSUBS VSUBS VSUBS VSUBS VSUBS VSUBS sky130_fd_sc_hd__nor2_1
Xsky130_fd_sc_hd__decap_3_2 VSUBS VSUBS VSUBS VSUBS sky130_fd_sc_hd__decap_3
Xsky130_fd_sc_hd__decap_12_918 VSUBS VSUBS VSUBS VSUBS sky130_fd_sc_hd__decap_12
Xsky130_fd_sc_hd__decap_12_929 VSUBS VSUBS VSUBS VSUBS sky130_fd_sc_hd__decap_12
Xsky130_fd_sc_hd__decap_12_907 VSUBS VSUBS VSUBS VSUBS sky130_fd_sc_hd__decap_12
Xsky130_fd_sc_hd__decap_12_759 VSUBS VSUBS VSUBS VSUBS sky130_fd_sc_hd__decap_12
Xsky130_fd_sc_hd__decap_12_748 VSUBS VSUBS VSUBS VSUBS sky130_fd_sc_hd__decap_12
Xsky130_fd_sc_hd__decap_12_726 VSUBS VSUBS VSUBS VSUBS sky130_fd_sc_hd__decap_12
Xsky130_fd_sc_hd__decap_12_737 VSUBS VSUBS VSUBS VSUBS sky130_fd_sc_hd__decap_12
Xsky130_fd_sc_hd__decap_12_704 VSUBS VSUBS VSUBS VSUBS sky130_fd_sc_hd__decap_12
Xsky130_fd_sc_hd__decap_12_715 VSUBS VSUBS VSUBS VSUBS sky130_fd_sc_hd__decap_12
Xsky130_fd_sc_hd__nor2_1_41 VSUBS VSUBS VSUBS VSUBS VSUBS VSUBS VSUBS sky130_fd_sc_hd__nor2_1
Xsky130_fd_sc_hd__nor2_1_52 VSUBS VSUBS VSUBS VSUBS VSUBS VSUBS VSUBS sky130_fd_sc_hd__nor2_1
Xsky130_fd_sc_hd__nor2_1_30 VSUBS VSUBS VSUBS VSUBS VSUBS sky130_fd_sc_hd__nor2_1_30/B
+ VSUBS sky130_fd_sc_hd__nor2_1
Xsky130_fd_sc_hd__nor2_1_74 VSUBS VSUBS VSUBS VSUBS VSUBS VSUBS VSUBS sky130_fd_sc_hd__nor2_1
Xsky130_fd_sc_hd__nor2_1_63 VSUBS VSUBS VSUBS VSUBS VSUBS VSUBS VSUBS sky130_fd_sc_hd__nor2_1
Xsky130_fd_sc_hd__nor2_1_85 VSUBS VSUBS VSUBS VSUBS VSUBS VSUBS VSUBS sky130_fd_sc_hd__nor2_1
Xsky130_fd_sc_hd__decap_12_534 VSUBS VSUBS VSUBS VSUBS sky130_fd_sc_hd__decap_12
Xsky130_fd_sc_hd__decap_12_523 VSUBS VSUBS VSUBS VSUBS sky130_fd_sc_hd__decap_12
Xsky130_fd_sc_hd__decap_12_501 VSUBS VSUBS VSUBS VSUBS sky130_fd_sc_hd__decap_12
Xsky130_fd_sc_hd__decap_12_512 VSUBS VSUBS VSUBS VSUBS sky130_fd_sc_hd__decap_12
Xsky130_fd_sc_hd__decap_12_578 VSUBS VSUBS VSUBS VSUBS sky130_fd_sc_hd__decap_12
Xsky130_fd_sc_hd__decap_12_589 VSUBS VSUBS VSUBS VSUBS sky130_fd_sc_hd__decap_12
Xsky130_fd_sc_hd__decap_12_567 VSUBS VSUBS VSUBS VSUBS sky130_fd_sc_hd__decap_12
Xsky130_fd_sc_hd__decap_12_556 VSUBS VSUBS VSUBS VSUBS sky130_fd_sc_hd__decap_12
Xsky130_fd_sc_hd__decap_12_545 VSUBS VSUBS VSUBS VSUBS sky130_fd_sc_hd__decap_12
Xsky130_fd_sc_hd__xnor2_1_5 VSUBS VSUBS VSUBS VSUBS VSUBS VSUBS VSUBS VSUBS VSUBS
+ sky130_fd_sc_hd__xnor2_1_5/a_377_297# sky130_fd_sc_hd__xnor2_1
Xsky130_fd_sc_hd__o22ai_1_0 VSUBS VSUBS VSUBS VSUBS VSUBS VSUBS VSUBS VSUBS VSUBS
+ VSUBS sky130_fd_sc_hd__o22ai_1
Xsky130_fd_sc_hd__decap_3_204 VSUBS VSUBS VSUBS VSUBS sky130_fd_sc_hd__decap_3
Xsky130_fd_sc_hd__decap_12_320 VSUBS VSUBS VSUBS VSUBS sky130_fd_sc_hd__decap_12
Xsky130_fd_sc_hd__decap_12_331 VSUBS VSUBS VSUBS VSUBS sky130_fd_sc_hd__decap_12
Xsky130_fd_sc_hd__decap_12_353 VSUBS VSUBS VSUBS VSUBS sky130_fd_sc_hd__decap_12
Xsky130_fd_sc_hd__decap_12_342 VSUBS VSUBS VSUBS VSUBS sky130_fd_sc_hd__decap_12
Xsky130_fd_sc_hd__decap_12_364 VSUBS VSUBS VSUBS VSUBS sky130_fd_sc_hd__decap_12
Xsky130_fd_sc_hd__decap_12_375 VSUBS VSUBS VSUBS VSUBS sky130_fd_sc_hd__decap_12
Xsky130_fd_sc_hd__decap_12_386 VSUBS VSUBS VSUBS VSUBS sky130_fd_sc_hd__decap_12
Xsky130_fd_sc_hd__decap_12_397 VSUBS VSUBS VSUBS VSUBS sky130_fd_sc_hd__decap_12
Xsky130_fd_sc_hd__clkinv_1_19 VSUBS VSUBS VSUBS VSUBS VSUBS VSUBS sky130_fd_sc_hd__clkinv_1
Xsky130_fd_sc_hd__nand2_1_35 VSUBS VSUBS VSUBS VSUBS VSUBS VSUBS VSUBS sky130_fd_sc_hd__nand2_1
Xsky130_fd_sc_hd__decap_12_194 VSUBS VSUBS VSUBS VSUBS sky130_fd_sc_hd__decap_12
Xsky130_fd_sc_hd__decap_12_183 VSUBS VSUBS VSUBS VSUBS sky130_fd_sc_hd__decap_12
Xsky130_fd_sc_hd__decap_12_161 VSUBS VSUBS VSUBS VSUBS sky130_fd_sc_hd__decap_12
Xsky130_fd_sc_hd__nand2_1_13 VSUBS VSUBS VSUBS VSUBS VSUBS VSUBS VSUBS sky130_fd_sc_hd__nand2_1
Xsky130_fd_sc_hd__nand2_1_24 VSUBS VSUBS VSUBS VSUBS VSUBS VSUBS VSUBS sky130_fd_sc_hd__nand2_1
Xsky130_fd_sc_hd__decap_12_150 VSUBS VSUBS VSUBS VSUBS sky130_fd_sc_hd__decap_12
Xsky130_fd_sc_hd__decap_12_172 VSUBS VSUBS VSUBS VSUBS sky130_fd_sc_hd__decap_12
Xsky130_fd_sc_hd__decap_4_13 VSUBS VSUBS VSUBS VSUBS sky130_fd_sc_hd__decap_4
Xsky130_fd_sc_hd__decap_4_24 VSUBS VSUBS VSUBS VSUBS sky130_fd_sc_hd__decap_4
Xsky130_fd_sc_hd__decap_8_159 VSUBS VSUBS VSUBS VSUBS sky130_fd_sc_hd__decap_8
Xsky130_fd_sc_hd__decap_4_68 VSUBS VSUBS VSUBS VSUBS sky130_fd_sc_hd__decap_4
Xsky130_fd_sc_hd__decap_4_79 VSUBS VSUBS VSUBS VSUBS sky130_fd_sc_hd__decap_4
Xsky130_fd_sc_hd__decap_4_57 VSUBS VSUBS VSUBS VSUBS sky130_fd_sc_hd__decap_4
Xsky130_fd_sc_hd__decap_8_137 VSUBS VSUBS VSUBS VSUBS sky130_fd_sc_hd__decap_8
Xsky130_fd_sc_hd__decap_8_148 VSUBS VSUBS VSUBS VSUBS sky130_fd_sc_hd__decap_8
Xsky130_fd_sc_hd__decap_4_46 VSUBS VSUBS VSUBS VSUBS sky130_fd_sc_hd__decap_4
Xsky130_fd_sc_hd__decap_8_104 VSUBS VSUBS VSUBS VSUBS sky130_fd_sc_hd__decap_8
Xsky130_fd_sc_hd__decap_8_115 VSUBS VSUBS VSUBS VSUBS sky130_fd_sc_hd__decap_8
Xsky130_fd_sc_hd__decap_4_35 VSUBS VSUBS VSUBS VSUBS sky130_fd_sc_hd__decap_4
Xsky130_fd_sc_hd__decap_8_126 VSUBS VSUBS VSUBS VSUBS sky130_fd_sc_hd__decap_8
Xsky130_fd_sc_hd__nor2_1_6 VSUBS VSUBS VSUBS VSUBS VSUBS VSUBS VSUBS sky130_fd_sc_hd__nor2_1
Xsky130_fd_sc_hd__decap_3_3 VSUBS VSUBS VSUBS VSUBS sky130_fd_sc_hd__decap_3
Xsky130_fd_sc_hd__decap_12_919 VSUBS VSUBS VSUBS VSUBS sky130_fd_sc_hd__decap_12
Xsky130_fd_sc_hd__decap_12_908 VSUBS VSUBS VSUBS VSUBS sky130_fd_sc_hd__decap_12
Xsky130_fd_sc_hd__decap_12_716 VSUBS VSUBS VSUBS VSUBS sky130_fd_sc_hd__decap_12
Xsky130_fd_sc_hd__decap_12_705 VSUBS VSUBS VSUBS VSUBS sky130_fd_sc_hd__decap_12
Xsky130_fd_sc_hd__decap_12_749 VSUBS VSUBS VSUBS VSUBS sky130_fd_sc_hd__decap_12
Xsky130_fd_sc_hd__decap_12_727 VSUBS VSUBS VSUBS VSUBS sky130_fd_sc_hd__decap_12
Xsky130_fd_sc_hd__decap_12_738 VSUBS VSUBS VSUBS VSUBS sky130_fd_sc_hd__decap_12
Xsky130_fd_sc_hd__nor2_1_75 VSUBS VSUBS VSUBS VSUBS VSUBS VSUBS VSUBS sky130_fd_sc_hd__nor2_1
Xsky130_fd_sc_hd__nor2_1_64 VSUBS VSUBS VSUBS VSUBS VSUBS VSUBS VSUBS sky130_fd_sc_hd__nor2_1
Xsky130_fd_sc_hd__nor2_1_42 VSUBS VSUBS VSUBS VSUBS VSUBS VSUBS VSUBS sky130_fd_sc_hd__nor2_1
Xsky130_fd_sc_hd__nor2_1_53 VSUBS VSUBS VSUBS VSUBS sky130_fd_sc_hd__nor2_1_53/A VSUBS
+ VSUBS sky130_fd_sc_hd__nor2_1
Xsky130_fd_sc_hd__nor2_1_31 VSUBS VSUBS VSUBS VSUBS VSUBS VSUBS VSUBS sky130_fd_sc_hd__nor2_1
Xsky130_fd_sc_hd__nor2_1_20 VSUBS VSUBS VSUBS VSUBS VSUBS VSUBS VSUBS sky130_fd_sc_hd__nor2_1
Xsky130_fd_sc_hd__decap_12_557 VSUBS VSUBS VSUBS VSUBS sky130_fd_sc_hd__decap_12
Xsky130_fd_sc_hd__decap_12_568 VSUBS VSUBS VSUBS VSUBS sky130_fd_sc_hd__decap_12
Xsky130_fd_sc_hd__decap_12_524 VSUBS VSUBS VSUBS VSUBS sky130_fd_sc_hd__decap_12
Xsky130_fd_sc_hd__decap_12_535 VSUBS VSUBS VSUBS VSUBS sky130_fd_sc_hd__decap_12
Xsky130_fd_sc_hd__decap_12_513 VSUBS VSUBS VSUBS VSUBS sky130_fd_sc_hd__decap_12
Xsky130_fd_sc_hd__decap_12_502 VSUBS VSUBS VSUBS VSUBS sky130_fd_sc_hd__decap_12
Xsky130_fd_sc_hd__decap_12_546 VSUBS VSUBS VSUBS VSUBS sky130_fd_sc_hd__decap_12
Xsky130_fd_sc_hd__decap_12_579 VSUBS VSUBS VSUBS VSUBS sky130_fd_sc_hd__decap_12
Xsky130_fd_sc_hd__xnor2_1_6 VSUBS VSUBS VSUBS VSUBS VSUBS VSUBS VSUBS VSUBS VSUBS
+ sky130_fd_sc_hd__xnor2_1_6/a_377_297# sky130_fd_sc_hd__xnor2_1
Xsky130_fd_sc_hd__o22ai_1_1 VSUBS VSUBS VSUBS VSUBS VSUBS VSUBS VSUBS VSUBS VSUBS
+ VSUBS sky130_fd_sc_hd__o22ai_1
Xsky130_fd_sc_hd__decap_3_205 VSUBS VSUBS VSUBS VSUBS sky130_fd_sc_hd__decap_3
Xsky130_fd_sc_hd__decap_12_310 VSUBS VSUBS VSUBS VSUBS sky130_fd_sc_hd__decap_12
Xsky130_fd_sc_hd__decap_12_343 VSUBS VSUBS VSUBS VSUBS sky130_fd_sc_hd__decap_12
Xsky130_fd_sc_hd__decap_12_321 VSUBS VSUBS VSUBS VSUBS sky130_fd_sc_hd__decap_12
Xsky130_fd_sc_hd__decap_12_365 VSUBS VSUBS VSUBS VSUBS sky130_fd_sc_hd__decap_12
Xsky130_fd_sc_hd__decap_12_354 VSUBS VSUBS VSUBS VSUBS sky130_fd_sc_hd__decap_12
Xsky130_fd_sc_hd__decap_12_332 VSUBS VSUBS VSUBS VSUBS sky130_fd_sc_hd__decap_12
Xsky130_fd_sc_hd__decap_12_376 VSUBS VSUBS VSUBS VSUBS sky130_fd_sc_hd__decap_12
Xsky130_fd_sc_hd__decap_12_398 VSUBS VSUBS VSUBS VSUBS sky130_fd_sc_hd__decap_12
Xsky130_fd_sc_hd__decap_12_387 VSUBS VSUBS VSUBS VSUBS sky130_fd_sc_hd__decap_12
Xsky130_fd_sc_hd__nand2_1_36 VSUBS VSUBS VSUBS VSUBS sky130_fd_sc_hd__nand2_1_36/A
+ VSUBS VSUBS sky130_fd_sc_hd__nand2_1
Xsky130_fd_sc_hd__decap_12_151 VSUBS VSUBS VSUBS VSUBS sky130_fd_sc_hd__decap_12
Xsky130_fd_sc_hd__decap_12_162 VSUBS VSUBS VSUBS VSUBS sky130_fd_sc_hd__decap_12
Xsky130_fd_sc_hd__nand2_1_25 VSUBS VSUBS VSUBS VSUBS VSUBS VSUBS VSUBS sky130_fd_sc_hd__nand2_1
Xsky130_fd_sc_hd__decap_12_140 VSUBS VSUBS VSUBS VSUBS sky130_fd_sc_hd__decap_12
Xsky130_fd_sc_hd__decap_12_173 VSUBS VSUBS VSUBS VSUBS sky130_fd_sc_hd__decap_12
Xsky130_fd_sc_hd__decap_12_184 VSUBS VSUBS VSUBS VSUBS sky130_fd_sc_hd__decap_12
Xsky130_fd_sc_hd__nand2_1_14 VSUBS VSUBS VSUBS VSUBS VSUBS VSUBS VSUBS sky130_fd_sc_hd__nand2_1
Xsky130_fd_sc_hd__decap_12_195 VSUBS VSUBS VSUBS VSUBS sky130_fd_sc_hd__decap_12
Xsky130_fd_sc_hd__decap_12_1150 VSUBS VSUBS VSUBS VSUBS sky130_fd_sc_hd__decap_12
Xsky130_fd_sc_hd__decap_4_47 VSUBS VSUBS VSUBS VSUBS sky130_fd_sc_hd__decap_4
Xsky130_fd_sc_hd__decap_4_14 VSUBS VSUBS VSUBS VSUBS sky130_fd_sc_hd__decap_4
Xsky130_fd_sc_hd__decap_4_25 VSUBS VSUBS VSUBS VSUBS sky130_fd_sc_hd__decap_4
Xsky130_fd_sc_hd__decap_4_36 VSUBS VSUBS VSUBS VSUBS sky130_fd_sc_hd__decap_4
Xsky130_fd_sc_hd__decap_4_69 VSUBS VSUBS VSUBS VSUBS sky130_fd_sc_hd__decap_4
Xsky130_fd_sc_hd__decap_8_138 VSUBS VSUBS VSUBS VSUBS sky130_fd_sc_hd__decap_8
Xsky130_fd_sc_hd__decap_4_58 VSUBS VSUBS VSUBS VSUBS sky130_fd_sc_hd__decap_4
Xsky130_fd_sc_hd__decap_8_149 VSUBS VSUBS VSUBS VSUBS sky130_fd_sc_hd__decap_8
Xsky130_fd_sc_hd__decap_8_105 VSUBS VSUBS VSUBS VSUBS sky130_fd_sc_hd__decap_8
Xsky130_fd_sc_hd__decap_8_116 VSUBS VSUBS VSUBS VSUBS sky130_fd_sc_hd__decap_8
Xsky130_fd_sc_hd__decap_8_127 VSUBS VSUBS VSUBS VSUBS sky130_fd_sc_hd__decap_8
Xsky130_fd_sc_hd__nor2_1_7 VSUBS VSUBS VSUBS VSUBS VSUBS VSUBS VSUBS sky130_fd_sc_hd__nor2_1
Xsky130_fd_sc_hd__decap_3_4 VSUBS VSUBS VSUBS VSUBS sky130_fd_sc_hd__decap_3
Xsky130_fd_sc_hd__decap_12_909 VSUBS VSUBS VSUBS VSUBS sky130_fd_sc_hd__decap_12
Xsky130_fd_sc_hd__decap_12_739 VSUBS VSUBS VSUBS VSUBS sky130_fd_sc_hd__decap_12
Xsky130_fd_sc_hd__decap_12_706 VSUBS VSUBS VSUBS VSUBS sky130_fd_sc_hd__decap_12
Xsky130_fd_sc_hd__decap_12_728 VSUBS VSUBS VSUBS VSUBS sky130_fd_sc_hd__decap_12
Xsky130_fd_sc_hd__decap_12_717 VSUBS VSUBS VSUBS VSUBS sky130_fd_sc_hd__decap_12
Xsky130_fd_sc_hd__nor2_1_76 VSUBS VSUBS VSUBS VSUBS VSUBS VSUBS VSUBS sky130_fd_sc_hd__nor2_1
Xsky130_fd_sc_hd__nor2_1_65 VSUBS VSUBS VSUBS VSUBS VSUBS VSUBS VSUBS sky130_fd_sc_hd__nor2_1
Xsky130_fd_sc_hd__nor2_1_43 VSUBS VSUBS VSUBS VSUBS VSUBS VSUBS VSUBS sky130_fd_sc_hd__nor2_1
Xsky130_fd_sc_hd__nor2_1_54 VSUBS VSUBS VSUBS VSUBS VSUBS VSUBS VSUBS sky130_fd_sc_hd__nor2_1
Xsky130_fd_sc_hd__nor2_1_10 VSUBS VSUBS VSUBS VSUBS VSUBS VSUBS VSUBS sky130_fd_sc_hd__nor2_1
Xsky130_fd_sc_hd__nor2_1_32 VSUBS VSUBS VSUBS VSUBS VSUBS VSUBS VSUBS sky130_fd_sc_hd__nor2_1
Xsky130_fd_sc_hd__nor2_1_21 VSUBS VSUBS VSUBS VSUBS VSUBS VSUBS VSUBS sky130_fd_sc_hd__nor2_1
Xsky130_fd_sc_hd__decap_12_569 VSUBS VSUBS VSUBS VSUBS sky130_fd_sc_hd__decap_12
Xsky130_fd_sc_hd__decap_12_558 VSUBS VSUBS VSUBS VSUBS sky130_fd_sc_hd__decap_12
Xsky130_fd_sc_hd__decap_12_525 VSUBS VSUBS VSUBS VSUBS sky130_fd_sc_hd__decap_12
Xsky130_fd_sc_hd__decap_12_547 VSUBS VSUBS VSUBS VSUBS sky130_fd_sc_hd__decap_12
Xsky130_fd_sc_hd__decap_12_536 VSUBS VSUBS VSUBS VSUBS sky130_fd_sc_hd__decap_12
Xsky130_fd_sc_hd__decap_12_514 VSUBS VSUBS VSUBS VSUBS sky130_fd_sc_hd__decap_12
Xsky130_fd_sc_hd__decap_12_503 VSUBS VSUBS VSUBS VSUBS sky130_fd_sc_hd__decap_12
Xsky130_fd_sc_hd__xnor2_1_7 VSUBS VSUBS VSUBS VSUBS VSUBS VSUBS VSUBS VSUBS VSUBS
+ sky130_fd_sc_hd__xnor2_1_7/a_377_297# sky130_fd_sc_hd__xnor2_1
Xsky130_fd_sc_hd__o22ai_1_2 VSUBS VSUBS VSUBS VSUBS VSUBS VSUBS VSUBS VSUBS VSUBS
+ VSUBS sky130_fd_sc_hd__o22ai_1
Xsky130_fd_sc_hd__decap_3_206 VSUBS VSUBS VSUBS VSUBS sky130_fd_sc_hd__decap_3
Xsky130_fd_sc_hd__decap_12_300 VSUBS VSUBS VSUBS VSUBS sky130_fd_sc_hd__decap_12
Xsky130_fd_sc_hd__decap_12_311 VSUBS VSUBS VSUBS VSUBS sky130_fd_sc_hd__decap_12
Xsky130_fd_sc_hd__decap_12_366 VSUBS VSUBS VSUBS VSUBS sky130_fd_sc_hd__decap_12
Xsky130_fd_sc_hd__decap_12_377 VSUBS VSUBS VSUBS VSUBS sky130_fd_sc_hd__decap_12
Xsky130_fd_sc_hd__decap_12_322 VSUBS VSUBS VSUBS VSUBS sky130_fd_sc_hd__decap_12
Xsky130_fd_sc_hd__decap_12_355 VSUBS VSUBS VSUBS VSUBS sky130_fd_sc_hd__decap_12
Xsky130_fd_sc_hd__decap_12_333 VSUBS VSUBS VSUBS VSUBS sky130_fd_sc_hd__decap_12
Xsky130_fd_sc_hd__decap_12_344 VSUBS VSUBS VSUBS VSUBS sky130_fd_sc_hd__decap_12
Xsky130_fd_sc_hd__decap_12_388 VSUBS VSUBS VSUBS VSUBS sky130_fd_sc_hd__decap_12
Xsky130_fd_sc_hd__decap_12_399 VSUBS VSUBS VSUBS VSUBS sky130_fd_sc_hd__decap_12
Xsky130_fd_sc_hd__a21boi_0_0 VSUBS VSUBS VSUBS VSUBS VSUBS VSUBS VSUBS VSUBS VSUBS
+ VSUBS sky130_fd_sc_hd__a21boi_0
Xsky130_fd_sc_hd__decap_8_90 VSUBS VSUBS VSUBS VSUBS sky130_fd_sc_hd__decap_8
Xsky130_fd_sc_hd__decap_12_141 VSUBS VSUBS VSUBS VSUBS sky130_fd_sc_hd__decap_12
Xsky130_fd_sc_hd__decap_12_130 VSUBS VSUBS VSUBS VSUBS sky130_fd_sc_hd__decap_12
Xsky130_fd_sc_hd__nand2_1_26 VSUBS VSUBS VSUBS VSUBS VSUBS VSUBS VSUBS sky130_fd_sc_hd__nand2_1
Xsky130_fd_sc_hd__nand2_1_37 VSUBS VSUBS VSUBS VSUBS VSUBS VSUBS VSUBS sky130_fd_sc_hd__nand2_1
Xsky130_fd_sc_hd__decap_12_163 VSUBS VSUBS VSUBS VSUBS sky130_fd_sc_hd__decap_12
Xsky130_fd_sc_hd__decap_12_152 VSUBS VSUBS VSUBS VSUBS sky130_fd_sc_hd__decap_12
Xsky130_fd_sc_hd__decap_12_174 VSUBS VSUBS VSUBS VSUBS sky130_fd_sc_hd__decap_12
Xsky130_fd_sc_hd__decap_12_185 VSUBS VSUBS VSUBS VSUBS sky130_fd_sc_hd__decap_12
Xsky130_fd_sc_hd__decap_12_196 VSUBS VSUBS VSUBS VSUBS sky130_fd_sc_hd__decap_12
Xsky130_fd_sc_hd__nand2_1_15 VSUBS VSUBS VSUBS VSUBS VSUBS VSUBS VSUBS sky130_fd_sc_hd__nand2_1
Xsky130_fd_sc_hd__decap_12_1140 VSUBS VSUBS VSUBS VSUBS sky130_fd_sc_hd__decap_12
Xsky130_fd_sc_hd__decap_12_1151 VSUBS VSUBS VSUBS VSUBS sky130_fd_sc_hd__decap_12
Xsky130_fd_sc_hd__decap_4_59 VSUBS VSUBS VSUBS VSUBS sky130_fd_sc_hd__decap_4
Xsky130_fd_sc_hd__decap_4_48 VSUBS VSUBS VSUBS VSUBS sky130_fd_sc_hd__decap_4
Xsky130_fd_sc_hd__decap_4_15 VSUBS VSUBS VSUBS VSUBS sky130_fd_sc_hd__decap_4
Xsky130_fd_sc_hd__decap_4_37 VSUBS VSUBS VSUBS VSUBS sky130_fd_sc_hd__decap_4
Xsky130_fd_sc_hd__decap_4_26 VSUBS VSUBS VSUBS VSUBS sky130_fd_sc_hd__decap_4
Xsky130_fd_sc_hd__decap_8_139 VSUBS VSUBS VSUBS VSUBS sky130_fd_sc_hd__decap_8
Xsky130_fd_sc_hd__decap_8_106 VSUBS VSUBS VSUBS VSUBS sky130_fd_sc_hd__decap_8
Xsky130_fd_sc_hd__decap_8_117 VSUBS VSUBS VSUBS VSUBS sky130_fd_sc_hd__decap_8
Xsky130_fd_sc_hd__decap_8_128 VSUBS VSUBS VSUBS VSUBS sky130_fd_sc_hd__decap_8
Xsky130_fd_sc_hd__nor2_1_8 VSUBS VSUBS VSUBS VSUBS VSUBS VSUBS VSUBS sky130_fd_sc_hd__nor2_1
Xsky130_fd_sc_hd__decap_3_5 VSUBS VSUBS VSUBS VSUBS sky130_fd_sc_hd__decap_3
Xsky130_fd_sc_hd__lpflow_isobufsrc_1_0 VSUBS VSUBS VSUBS VSUBS sky130_fd_sc_hd__dfxtp_1_64/Q
+ VSUBS VSUBS VSUBS sky130_fd_sc_hd__lpflow_isobufsrc_1
Xsky130_fd_sc_hd__decap_12_718 VSUBS VSUBS VSUBS VSUBS sky130_fd_sc_hd__decap_12
Xsky130_fd_sc_hd__decap_12_707 VSUBS VSUBS VSUBS VSUBS sky130_fd_sc_hd__decap_12
Xsky130_fd_sc_hd__decap_12_729 VSUBS VSUBS VSUBS VSUBS sky130_fd_sc_hd__decap_12
Xsky130_fd_sc_hd__nor2_1_11 VSUBS VSUBS VSUBS VSUBS VSUBS VSUBS VSUBS sky130_fd_sc_hd__nor2_1
Xsky130_fd_sc_hd__nor2_1_77 VSUBS VSUBS VSUBS VSUBS VSUBS VSUBS VSUBS sky130_fd_sc_hd__nor2_1
Xsky130_fd_sc_hd__nor2_1_66 VSUBS VSUBS VSUBS VSUBS VSUBS VSUBS VSUBS sky130_fd_sc_hd__nor2_1
Xsky130_fd_sc_hd__nor2_1_44 VSUBS VSUBS VSUBS VSUBS VSUBS VSUBS VSUBS sky130_fd_sc_hd__nor2_1
Xsky130_fd_sc_hd__nor2_1_55 VSUBS VSUBS VSUBS VSUBS VSUBS VSUBS VSUBS sky130_fd_sc_hd__nor2_1
Xsky130_fd_sc_hd__nor2_1_33 VSUBS VSUBS VSUBS VSUBS VSUBS VSUBS VSUBS sky130_fd_sc_hd__nor2_1
Xsky130_fd_sc_hd__nor2_1_22 VSUBS VSUBS VSUBS VSUBS VSUBS VSUBS VSUBS sky130_fd_sc_hd__nor2_1
Xsky130_fd_sc_hd__decap_12_559 VSUBS VSUBS VSUBS VSUBS sky130_fd_sc_hd__decap_12
Xsky130_fd_sc_hd__decap_12_526 VSUBS VSUBS VSUBS VSUBS sky130_fd_sc_hd__decap_12
Xsky130_fd_sc_hd__decap_12_537 VSUBS VSUBS VSUBS VSUBS sky130_fd_sc_hd__decap_12
Xsky130_fd_sc_hd__decap_12_515 VSUBS VSUBS VSUBS VSUBS sky130_fd_sc_hd__decap_12
Xsky130_fd_sc_hd__decap_12_504 VSUBS VSUBS VSUBS VSUBS sky130_fd_sc_hd__decap_12
Xsky130_fd_sc_hd__decap_12_548 VSUBS VSUBS VSUBS VSUBS sky130_fd_sc_hd__decap_12
Xsky130_fd_sc_hd__xnor2_1_8 VSUBS VSUBS VSUBS VSUBS VSUBS VSUBS VSUBS VSUBS VSUBS
+ sky130_fd_sc_hd__xnor2_1_8/a_377_297# sky130_fd_sc_hd__xnor2_1
Xsky130_fd_sc_hd__decap_12_312 VSUBS VSUBS VSUBS VSUBS sky130_fd_sc_hd__decap_12
Xsky130_fd_sc_hd__decap_12_301 VSUBS VSUBS VSUBS VSUBS sky130_fd_sc_hd__decap_12
Xsky130_fd_sc_hd__decap_12_323 VSUBS VSUBS VSUBS VSUBS sky130_fd_sc_hd__decap_12
Xsky130_fd_sc_hd__decap_12_334 VSUBS VSUBS VSUBS VSUBS sky130_fd_sc_hd__decap_12
Xsky130_fd_sc_hd__decap_12_367 VSUBS VSUBS VSUBS VSUBS sky130_fd_sc_hd__decap_12
Xsky130_fd_sc_hd__decap_12_378 VSUBS VSUBS VSUBS VSUBS sky130_fd_sc_hd__decap_12
Xsky130_fd_sc_hd__decap_12_345 VSUBS VSUBS VSUBS VSUBS sky130_fd_sc_hd__decap_12
Xsky130_fd_sc_hd__decap_12_356 VSUBS VSUBS VSUBS VSUBS sky130_fd_sc_hd__decap_12
Xsky130_fd_sc_hd__decap_12_389 VSUBS VSUBS VSUBS VSUBS sky130_fd_sc_hd__decap_12
Xsky130_fd_sc_hd__decap_12_890 VSUBS VSUBS VSUBS VSUBS sky130_fd_sc_hd__decap_12
Xsky130_fd_sc_hd__a21boi_0_1 VSUBS VSUBS VSUBS VSUBS VSUBS VSUBS VSUBS VSUBS VSUBS
+ VSUBS sky130_fd_sc_hd__a21boi_0
Xsky130_fd_sc_hd__decap_8_80 VSUBS VSUBS VSUBS VSUBS sky130_fd_sc_hd__decap_8
Xsky130_fd_sc_hd__decap_8_91 VSUBS VSUBS VSUBS VSUBS sky130_fd_sc_hd__decap_8
Xsky130_fd_sc_hd__decap_12_120 VSUBS VSUBS VSUBS VSUBS sky130_fd_sc_hd__decap_12
Xsky130_fd_sc_hd__decap_12_153 VSUBS VSUBS VSUBS VSUBS sky130_fd_sc_hd__decap_12
Xsky130_fd_sc_hd__decap_12_142 VSUBS VSUBS VSUBS VSUBS sky130_fd_sc_hd__decap_12
Xsky130_fd_sc_hd__decap_12_164 VSUBS VSUBS VSUBS VSUBS sky130_fd_sc_hd__decap_12
Xsky130_fd_sc_hd__decap_12_175 VSUBS VSUBS VSUBS VSUBS sky130_fd_sc_hd__decap_12
Xsky130_fd_sc_hd__decap_12_131 VSUBS VSUBS VSUBS VSUBS sky130_fd_sc_hd__decap_12
Xsky130_fd_sc_hd__nand2_1_38 VSUBS VSUBS VSUBS VSUBS sky130_fd_sc_hd__nand2_1_38/A
+ VSUBS VSUBS sky130_fd_sc_hd__nand2_1
Xsky130_fd_sc_hd__nand2_1_27 VSUBS VSUBS VSUBS VSUBS VSUBS VSUBS VSUBS sky130_fd_sc_hd__nand2_1
Xsky130_fd_sc_hd__nand2_1_16 VSUBS VSUBS VSUBS VSUBS VSUBS VSUBS VSUBS sky130_fd_sc_hd__nand2_1
Xsky130_fd_sc_hd__decap_12_186 VSUBS VSUBS VSUBS VSUBS sky130_fd_sc_hd__decap_12
Xsky130_fd_sc_hd__decap_12_197 VSUBS VSUBS VSUBS VSUBS sky130_fd_sc_hd__decap_12
Xsky130_fd_sc_hd__decap_12_1141 VSUBS VSUBS VSUBS VSUBS sky130_fd_sc_hd__decap_12
Xsky130_fd_sc_hd__decap_12_1130 VSUBS VSUBS VSUBS VSUBS sky130_fd_sc_hd__decap_12
Xsky130_fd_sc_hd__decap_12_1152 VSUBS VSUBS VSUBS VSUBS sky130_fd_sc_hd__decap_12
Xsky130_fd_sc_hd__decap_4_16 VSUBS VSUBS VSUBS VSUBS sky130_fd_sc_hd__decap_4
Xsky130_fd_sc_hd__decap_4_49 VSUBS VSUBS VSUBS VSUBS sky130_fd_sc_hd__decap_4
Xsky130_fd_sc_hd__decap_4_27 VSUBS VSUBS VSUBS VSUBS sky130_fd_sc_hd__decap_4
Xsky130_fd_sc_hd__decap_4_38 VSUBS VSUBS VSUBS VSUBS sky130_fd_sc_hd__decap_4
Xsky130_fd_sc_hd__decap_8_107 VSUBS VSUBS VSUBS VSUBS sky130_fd_sc_hd__decap_8
Xsky130_fd_sc_hd__decap_8_129 VSUBS VSUBS VSUBS VSUBS sky130_fd_sc_hd__decap_8
Xsky130_fd_sc_hd__decap_8_118 VSUBS VSUBS VSUBS VSUBS sky130_fd_sc_hd__decap_8
Xsky130_fd_sc_hd__nor2_1_9 VSUBS VSUBS VSUBS VSUBS VSUBS VSUBS VSUBS sky130_fd_sc_hd__nor2_1
Xsky130_fd_sc_hd__decap_3_6 VSUBS VSUBS VSUBS VSUBS sky130_fd_sc_hd__decap_3
Xsky130_fd_sc_hd__lpflow_isobufsrc_1_1 VSUBS VSUBS VSUBS VSUBS VSUBS VSUBS VSUBS VSUBS
+ sky130_fd_sc_hd__lpflow_isobufsrc_1
Xsky130_fd_sc_hd__decap_12_708 VSUBS VSUBS VSUBS VSUBS sky130_fd_sc_hd__decap_12
Xsky130_fd_sc_hd__decap_12_719 VSUBS VSUBS VSUBS VSUBS sky130_fd_sc_hd__decap_12
Xsky130_fd_sc_hd__nor2_1_12 VSUBS VSUBS VSUBS VSUBS VSUBS VSUBS VSUBS sky130_fd_sc_hd__nor2_1
Xsky130_fd_sc_hd__nor2_1_34 VSUBS VSUBS VSUBS VSUBS VSUBS VSUBS VSUBS sky130_fd_sc_hd__nor2_1
Xsky130_fd_sc_hd__nor2_1_23 VSUBS VSUBS VSUBS VSUBS VSUBS VSUBS VSUBS sky130_fd_sc_hd__nor2_1
Xsky130_fd_sc_hd__nor2_1_78 VSUBS VSUBS VSUBS VSUBS VSUBS VSUBS VSUBS sky130_fd_sc_hd__nor2_1
Xsky130_fd_sc_hd__nor2_1_67 VSUBS VSUBS VSUBS VSUBS VSUBS VSUBS VSUBS sky130_fd_sc_hd__nor2_1
Xsky130_fd_sc_hd__nor2_1_45 VSUBS VSUBS VSUBS VSUBS VSUBS VSUBS VSUBS sky130_fd_sc_hd__nor2_1
Xsky130_fd_sc_hd__nor2_1_56 VSUBS VSUBS VSUBS VSUBS VSUBS VSUBS VSUBS sky130_fd_sc_hd__nor2_1
Xsky130_fd_sc_hd__decap_12_516 VSUBS VSUBS VSUBS VSUBS sky130_fd_sc_hd__decap_12
Xsky130_fd_sc_hd__decap_12_505 VSUBS VSUBS VSUBS VSUBS sky130_fd_sc_hd__decap_12
Xsky130_fd_sc_hd__decap_12_538 VSUBS VSUBS VSUBS VSUBS sky130_fd_sc_hd__decap_12
Xsky130_fd_sc_hd__decap_12_527 VSUBS VSUBS VSUBS VSUBS sky130_fd_sc_hd__decap_12
Xsky130_fd_sc_hd__decap_12_549 VSUBS VSUBS VSUBS VSUBS sky130_fd_sc_hd__decap_12
Xsky130_fd_sc_hd__xnor2_1_9 VSUBS VSUBS VSUBS VSUBS VSUBS VSUBS VSUBS VSUBS VSUBS
+ sky130_fd_sc_hd__xnor2_1_9/a_377_297# sky130_fd_sc_hd__xnor2_1
Xsky130_fd_sc_hd__decap_12_313 VSUBS VSUBS VSUBS VSUBS sky130_fd_sc_hd__decap_12
Xsky130_fd_sc_hd__decap_12_302 VSUBS VSUBS VSUBS VSUBS sky130_fd_sc_hd__decap_12
Xsky130_fd_sc_hd__decap_12_346 VSUBS VSUBS VSUBS VSUBS sky130_fd_sc_hd__decap_12
Xsky130_fd_sc_hd__decap_12_368 VSUBS VSUBS VSUBS VSUBS sky130_fd_sc_hd__decap_12
Xsky130_fd_sc_hd__decap_12_335 VSUBS VSUBS VSUBS VSUBS sky130_fd_sc_hd__decap_12
Xsky130_fd_sc_hd__decap_12_324 VSUBS VSUBS VSUBS VSUBS sky130_fd_sc_hd__decap_12
Xsky130_fd_sc_hd__decap_12_357 VSUBS VSUBS VSUBS VSUBS sky130_fd_sc_hd__decap_12
Xsky130_fd_sc_hd__decap_12_379 VSUBS VSUBS VSUBS VSUBS sky130_fd_sc_hd__decap_12
Xsky130_fd_sc_hd__decap_12_891 VSUBS VSUBS VSUBS VSUBS sky130_fd_sc_hd__decap_12
Xsky130_fd_sc_hd__decap_12_880 VSUBS VSUBS VSUBS VSUBS sky130_fd_sc_hd__decap_12
Xsky130_fd_sc_hd__decap_8_81 VSUBS VSUBS VSUBS VSUBS sky130_fd_sc_hd__decap_8
Xsky130_fd_sc_hd__decap_8_70 VSUBS VSUBS VSUBS VSUBS sky130_fd_sc_hd__decap_8
Xsky130_fd_sc_hd__decap_8_92 VSUBS VSUBS VSUBS VSUBS sky130_fd_sc_hd__decap_8
Xsky130_fd_sc_hd__nand2_1_28 VSUBS VSUBS VSUBS VSUBS VSUBS VSUBS VSUBS sky130_fd_sc_hd__nand2_1
Xsky130_fd_sc_hd__nand2_1_39 VSUBS VSUBS VSUBS VSUBS VSUBS VSUBS VSUBS sky130_fd_sc_hd__nand2_1
Xsky130_fd_sc_hd__decap_12_198 VSUBS VSUBS VSUBS VSUBS sky130_fd_sc_hd__decap_12
Xsky130_fd_sc_hd__decap_12_154 VSUBS VSUBS VSUBS VSUBS sky130_fd_sc_hd__decap_12
Xsky130_fd_sc_hd__decap_12_121 VSUBS VSUBS VSUBS VSUBS sky130_fd_sc_hd__decap_12
Xsky130_fd_sc_hd__decap_12_110 VSUBS VSUBS VSUBS VSUBS sky130_fd_sc_hd__decap_12
Xsky130_fd_sc_hd__nand2_1_17 VSUBS VSUBS VSUBS VSUBS VSUBS VSUBS VSUBS sky130_fd_sc_hd__nand2_1
Xsky130_fd_sc_hd__decap_12_187 VSUBS VSUBS VSUBS VSUBS sky130_fd_sc_hd__decap_12
Xsky130_fd_sc_hd__decap_12_176 VSUBS VSUBS VSUBS VSUBS sky130_fd_sc_hd__decap_12
Xsky130_fd_sc_hd__decap_12_143 VSUBS VSUBS VSUBS VSUBS sky130_fd_sc_hd__decap_12
Xsky130_fd_sc_hd__decap_12_132 VSUBS VSUBS VSUBS VSUBS sky130_fd_sc_hd__decap_12
Xsky130_fd_sc_hd__decap_12_165 VSUBS VSUBS VSUBS VSUBS sky130_fd_sc_hd__decap_12
Xsky130_fd_sc_hd__decap_12_1120 VSUBS VSUBS VSUBS VSUBS sky130_fd_sc_hd__decap_12
Xsky130_fd_sc_hd__decap_12_1142 VSUBS VSUBS VSUBS VSUBS sky130_fd_sc_hd__decap_12
Xsky130_fd_sc_hd__decap_12_1131 VSUBS VSUBS VSUBS VSUBS sky130_fd_sc_hd__decap_12
Xsky130_fd_sc_hd__decap_12_1153 VSUBS VSUBS VSUBS VSUBS sky130_fd_sc_hd__decap_12
Xsky130_fd_sc_hd__decap_4_17 VSUBS VSUBS VSUBS VSUBS sky130_fd_sc_hd__decap_4
Xsky130_fd_sc_hd__decap_4_39 VSUBS VSUBS VSUBS VSUBS sky130_fd_sc_hd__decap_4
Xsky130_fd_sc_hd__decap_8_108 VSUBS VSUBS VSUBS VSUBS sky130_fd_sc_hd__decap_8
Xsky130_fd_sc_hd__decap_4_28 VSUBS VSUBS VSUBS VSUBS sky130_fd_sc_hd__decap_4
Xsky130_fd_sc_hd__decap_8_119 VSUBS VSUBS VSUBS VSUBS sky130_fd_sc_hd__decap_8
Xsky130_fd_sc_hd__decap_12_0 VSUBS VSUBS VSUBS VSUBS sky130_fd_sc_hd__decap_12
Xsky130_fd_sc_hd__decap_3_7 VSUBS VSUBS VSUBS VSUBS sky130_fd_sc_hd__decap_3
Xsky130_fd_sc_hd__decap_4_100 VSUBS VSUBS VSUBS VSUBS sky130_fd_sc_hd__decap_4
Xsky130_fd_sc_hd__lpflow_isobufsrc_1_2 VSUBS VSUBS VSUBS VSUBS VSUBS VSUBS VSUBS VSUBS
+ sky130_fd_sc_hd__lpflow_isobufsrc_1
Xsky130_fd_sc_hd__decap_12_709 VSUBS VSUBS VSUBS VSUBS sky130_fd_sc_hd__decap_12
Xsky130_fd_sc_hd__decap_8_280 VSUBS VSUBS VSUBS VSUBS sky130_fd_sc_hd__decap_8
Xsky130_fd_sc_hd__nor2_1_68 VSUBS VSUBS VSUBS VSUBS sky130_fd_sc_hd__nor2_1_68/A VSUBS
+ VSUBS sky130_fd_sc_hd__nor2_1
Xsky130_fd_sc_hd__nor2_1_57 VSUBS VSUBS VSUBS VSUBS VSUBS VSUBS VSUBS sky130_fd_sc_hd__nor2_1
Xsky130_fd_sc_hd__nor2_1_46 VSUBS VSUBS VSUBS VSUBS VSUBS VSUBS VSUBS sky130_fd_sc_hd__nor2_1
Xsky130_fd_sc_hd__nor2_1_13 VSUBS VSUBS VSUBS VSUBS VSUBS VSUBS VSUBS sky130_fd_sc_hd__nor2_1
Xsky130_fd_sc_hd__nor2_1_35 VSUBS VSUBS VSUBS VSUBS VSUBS VSUBS VSUBS sky130_fd_sc_hd__nor2_1
Xsky130_fd_sc_hd__nor2_1_24 VSUBS VSUBS VSUBS VSUBS VSUBS VSUBS VSUBS sky130_fd_sc_hd__nor2_1
Xsky130_fd_sc_hd__nor2_1_79 VSUBS VSUBS VSUBS VSUBS sky130_fd_sc_hd__nor2_1_79/A VSUBS
+ VSUBS sky130_fd_sc_hd__nor2_1
Xsky130_fd_sc_hd__decap_12_539 VSUBS VSUBS VSUBS VSUBS sky130_fd_sc_hd__decap_12
Xsky130_fd_sc_hd__decap_12_528 VSUBS VSUBS VSUBS VSUBS sky130_fd_sc_hd__decap_12
Xsky130_fd_sc_hd__decap_12_517 VSUBS VSUBS VSUBS VSUBS sky130_fd_sc_hd__decap_12
Xsky130_fd_sc_hd__decap_12_506 VSUBS VSUBS VSUBS VSUBS sky130_fd_sc_hd__decap_12
Xsky130_fd_sc_hd__decap_12_303 VSUBS VSUBS VSUBS VSUBS sky130_fd_sc_hd__decap_12
Xsky130_fd_sc_hd__decap_12_314 VSUBS VSUBS VSUBS VSUBS sky130_fd_sc_hd__decap_12
Xsky130_fd_sc_hd__decap_12_369 VSUBS VSUBS VSUBS VSUBS sky130_fd_sc_hd__decap_12
Xsky130_fd_sc_hd__decap_12_347 VSUBS VSUBS VSUBS VSUBS sky130_fd_sc_hd__decap_12
Xsky130_fd_sc_hd__decap_12_336 VSUBS VSUBS VSUBS VSUBS sky130_fd_sc_hd__decap_12
Xsky130_fd_sc_hd__decap_12_325 VSUBS VSUBS VSUBS VSUBS sky130_fd_sc_hd__decap_12
Xsky130_fd_sc_hd__decap_12_358 VSUBS VSUBS VSUBS VSUBS sky130_fd_sc_hd__decap_12
Xsky130_fd_sc_hd__decap_12_881 VSUBS VSUBS VSUBS VSUBS sky130_fd_sc_hd__decap_12
Xsky130_fd_sc_hd__decap_12_870 VSUBS VSUBS VSUBS VSUBS sky130_fd_sc_hd__decap_12
Xsky130_fd_sc_hd__decap_12_892 VSUBS VSUBS VSUBS VSUBS sky130_fd_sc_hd__decap_12
Xsky130_fd_sc_hd__decap_8_82 VSUBS VSUBS VSUBS VSUBS sky130_fd_sc_hd__decap_8
Xsky130_fd_sc_hd__decap_8_93 VSUBS VSUBS VSUBS VSUBS sky130_fd_sc_hd__decap_8
Xsky130_fd_sc_hd__decap_8_71 VSUBS VSUBS VSUBS VSUBS sky130_fd_sc_hd__decap_8
Xsky130_fd_sc_hd__decap_8_60 VSUBS VSUBS VSUBS VSUBS sky130_fd_sc_hd__decap_8
Xsky130_fd_sc_hd__decap_12_100 VSUBS VSUBS VSUBS VSUBS sky130_fd_sc_hd__decap_12
Xsky130_fd_sc_hd__nand2_1_29 VSUBS VSUBS VSUBS VSUBS VSUBS VSUBS VSUBS sky130_fd_sc_hd__nand2_1
Xsky130_fd_sc_hd__nand2_1_18 VSUBS VSUBS VSUBS VSUBS VSUBS VSUBS VSUBS sky130_fd_sc_hd__nand2_1
Xsky130_fd_sc_hd__decap_12_155 VSUBS VSUBS VSUBS VSUBS sky130_fd_sc_hd__decap_12
Xsky130_fd_sc_hd__decap_12_122 VSUBS VSUBS VSUBS VSUBS sky130_fd_sc_hd__decap_12
Xsky130_fd_sc_hd__decap_12_111 VSUBS VSUBS VSUBS VSUBS sky130_fd_sc_hd__decap_12
Xsky130_fd_sc_hd__decap_12_144 VSUBS VSUBS VSUBS VSUBS sky130_fd_sc_hd__decap_12
Xsky130_fd_sc_hd__decap_12_188 VSUBS VSUBS VSUBS VSUBS sky130_fd_sc_hd__decap_12
Xsky130_fd_sc_hd__decap_12_177 VSUBS VSUBS VSUBS VSUBS sky130_fd_sc_hd__decap_12
Xsky130_fd_sc_hd__decap_12_166 VSUBS VSUBS VSUBS VSUBS sky130_fd_sc_hd__decap_12
Xsky130_fd_sc_hd__decap_12_133 VSUBS VSUBS VSUBS VSUBS sky130_fd_sc_hd__decap_12
Xsky130_fd_sc_hd__decap_12_199 VSUBS VSUBS VSUBS VSUBS sky130_fd_sc_hd__decap_12
Xsky130_fd_sc_hd__decap_12_1110 VSUBS VSUBS VSUBS VSUBS sky130_fd_sc_hd__decap_12
Xsky130_fd_sc_hd__decap_12_1121 VSUBS VSUBS VSUBS VSUBS sky130_fd_sc_hd__decap_12
Xsky130_fd_sc_hd__decap_12_1143 VSUBS VSUBS VSUBS VSUBS sky130_fd_sc_hd__decap_12
Xsky130_fd_sc_hd__decap_12_1132 VSUBS VSUBS VSUBS VSUBS sky130_fd_sc_hd__decap_12
Xsky130_fd_sc_hd__nand3_1_0 VSUBS VSUBS VSUBS VSUBS VSUBS VSUBS VSUBS VSUBS sky130_fd_sc_hd__nand3_1
Xsky130_fd_sc_hd__decap_12_1154 VSUBS VSUBS VSUBS VSUBS sky130_fd_sc_hd__decap_12
Xsky130_fd_sc_hd__decap_4_18 VSUBS VSUBS VSUBS VSUBS sky130_fd_sc_hd__decap_4
Xsky130_fd_sc_hd__decap_4_29 VSUBS VSUBS VSUBS VSUBS sky130_fd_sc_hd__decap_4
Xsky130_fd_sc_hd__decap_8_109 VSUBS VSUBS VSUBS VSUBS sky130_fd_sc_hd__decap_8
Xsky130_fd_sc_hd__decap_12_1 VSUBS VSUBS VSUBS VSUBS sky130_fd_sc_hd__decap_12
Xsky130_fd_sc_hd__decap_3_8 VSUBS VSUBS VSUBS VSUBS sky130_fd_sc_hd__decap_3
Xsky130_fd_sc_hd__decap_4_101 VSUBS VSUBS VSUBS VSUBS sky130_fd_sc_hd__decap_4
Xsky130_fd_sc_hd__decap_8_270 VSUBS VSUBS VSUBS VSUBS sky130_fd_sc_hd__decap_8
Xsky130_fd_sc_hd__nor2_1_69 VSUBS VSUBS VSUBS VSUBS VSUBS VSUBS VSUBS sky130_fd_sc_hd__nor2_1
Xsky130_fd_sc_hd__nor2_1_47 VSUBS VSUBS VSUBS VSUBS VSUBS VSUBS VSUBS sky130_fd_sc_hd__nor2_1
Xsky130_fd_sc_hd__nor2_1_58 VSUBS VSUBS VSUBS VSUBS VSUBS VSUBS VSUBS sky130_fd_sc_hd__nor2_1
Xsky130_fd_sc_hd__nor2_1_25 VSUBS VSUBS VSUBS VSUBS VSUBS VSUBS VSUBS sky130_fd_sc_hd__nor2_1
Xsky130_fd_sc_hd__nor2_1_14 VSUBS VSUBS VSUBS VSUBS VSUBS VSUBS VSUBS sky130_fd_sc_hd__nor2_1
Xsky130_fd_sc_hd__nor2_1_36 VSUBS VSUBS VSUBS VSUBS VSUBS VSUBS VSUBS sky130_fd_sc_hd__nor2_1
Xsky130_fd_sc_hd__decap_12_529 VSUBS VSUBS VSUBS VSUBS sky130_fd_sc_hd__decap_12
Xsky130_fd_sc_hd__decap_12_518 VSUBS VSUBS VSUBS VSUBS sky130_fd_sc_hd__decap_12
Xsky130_fd_sc_hd__decap_12_507 VSUBS VSUBS VSUBS VSUBS sky130_fd_sc_hd__decap_12
Xsky130_fd_sc_hd__decap_12_315 VSUBS VSUBS VSUBS VSUBS sky130_fd_sc_hd__decap_12
Xsky130_fd_sc_hd__decap_12_304 VSUBS VSUBS VSUBS VSUBS sky130_fd_sc_hd__decap_12
Xsky130_fd_sc_hd__decap_12_337 VSUBS VSUBS VSUBS VSUBS sky130_fd_sc_hd__decap_12
Xsky130_fd_sc_hd__decap_12_326 VSUBS VSUBS VSUBS VSUBS sky130_fd_sc_hd__decap_12
Xsky130_fd_sc_hd__decap_12_348 VSUBS VSUBS VSUBS VSUBS sky130_fd_sc_hd__decap_12
Xsky130_fd_sc_hd__decap_12_359 VSUBS VSUBS VSUBS VSUBS sky130_fd_sc_hd__decap_12
Xsky130_fd_sc_hd__decap_12_860 VSUBS VSUBS VSUBS VSUBS sky130_fd_sc_hd__decap_12
Xsky130_fd_sc_hd__decap_12_871 VSUBS VSUBS VSUBS VSUBS sky130_fd_sc_hd__decap_12
Xsky130_fd_sc_hd__decap_12_882 VSUBS VSUBS VSUBS VSUBS sky130_fd_sc_hd__decap_12
Xsky130_fd_sc_hd__decap_12_893 VSUBS VSUBS VSUBS VSUBS sky130_fd_sc_hd__decap_12
Xsky130_fd_sc_hd__decap_8_83 VSUBS VSUBS VSUBS VSUBS sky130_fd_sc_hd__decap_8
Xsky130_fd_sc_hd__decap_8_94 VSUBS VSUBS VSUBS VSUBS sky130_fd_sc_hd__decap_8
Xsky130_fd_sc_hd__decap_8_72 VSUBS VSUBS VSUBS VSUBS sky130_fd_sc_hd__decap_8
Xsky130_fd_sc_hd__decap_8_50 VSUBS VSUBS VSUBS VSUBS sky130_fd_sc_hd__decap_8
Xsky130_fd_sc_hd__decap_8_61 VSUBS VSUBS VSUBS VSUBS sky130_fd_sc_hd__decap_8
Xsky130_fd_sc_hd__decap_12_101 VSUBS VSUBS VSUBS VSUBS sky130_fd_sc_hd__decap_12
Xsky130_fd_sc_hd__decap_12_112 VSUBS VSUBS VSUBS VSUBS sky130_fd_sc_hd__decap_12
Xsky130_fd_sc_hd__decap_12_123 VSUBS VSUBS VSUBS VSUBS sky130_fd_sc_hd__decap_12
Xsky130_fd_sc_hd__decap_12_145 VSUBS VSUBS VSUBS VSUBS sky130_fd_sc_hd__decap_12
Xsky130_fd_sc_hd__decap_12_156 VSUBS VSUBS VSUBS VSUBS sky130_fd_sc_hd__decap_12
Xsky130_fd_sc_hd__nand2_1_19 VSUBS VSUBS VSUBS VSUBS VSUBS VSUBS VSUBS sky130_fd_sc_hd__nand2_1
Xsky130_fd_sc_hd__decap_12_178 VSUBS VSUBS VSUBS VSUBS sky130_fd_sc_hd__decap_12
Xsky130_fd_sc_hd__decap_12_189 VSUBS VSUBS VSUBS VSUBS sky130_fd_sc_hd__decap_12
Xsky130_fd_sc_hd__decap_12_134 VSUBS VSUBS VSUBS VSUBS sky130_fd_sc_hd__decap_12
Xsky130_fd_sc_hd__decap_12_167 VSUBS VSUBS VSUBS VSUBS sky130_fd_sc_hd__decap_12
Xsky130_fd_sc_hd__decap_12_1100 VSUBS VSUBS VSUBS VSUBS sky130_fd_sc_hd__decap_12
Xsky130_fd_sc_hd__decap_12_1111 VSUBS VSUBS VSUBS VSUBS sky130_fd_sc_hd__decap_12
Xsky130_fd_sc_hd__decap_12_1122 VSUBS VSUBS VSUBS VSUBS sky130_fd_sc_hd__decap_12
Xsky130_fd_sc_hd__decap_12_1144 VSUBS VSUBS VSUBS VSUBS sky130_fd_sc_hd__decap_12
Xsky130_fd_sc_hd__decap_12_1133 VSUBS VSUBS VSUBS VSUBS sky130_fd_sc_hd__decap_12
Xsky130_fd_sc_hd__decap_12_1155 VSUBS VSUBS VSUBS VSUBS sky130_fd_sc_hd__decap_12
Xsky130_fd_sc_hd__nand3_1_1 VSUBS VSUBS VSUBS VSUBS VSUBS VSUBS VSUBS sky130_fd_sc_hd__nand3_1_1/C
+ sky130_fd_sc_hd__nand3_1
Xsky130_fd_sc_hd__decap_4_19 VSUBS VSUBS VSUBS VSUBS sky130_fd_sc_hd__decap_4
Xsky130_fd_sc_hd__decap_12_690 VSUBS VSUBS VSUBS VSUBS sky130_fd_sc_hd__decap_12
Xsky130_fd_sc_hd__decap_12_2 VSUBS VSUBS VSUBS VSUBS sky130_fd_sc_hd__decap_12
Xsky130_fd_sc_hd__o21ba_1_0 VSUBS VSUBS VSUBS VSUBS VSUBS VSUBS VSUBS VSUBS VSUBS
+ VSUBS VSUBS sky130_fd_sc_hd__o21ba_1
Xsky130_fd_sc_hd__decap_3_9 VSUBS VSUBS VSUBS VSUBS sky130_fd_sc_hd__decap_3
Xsky130_fd_sc_hd__decap_4_102 VSUBS VSUBS VSUBS VSUBS sky130_fd_sc_hd__decap_4
Xsky130_fd_sc_hd__decap_3_190 VSUBS VSUBS VSUBS VSUBS sky130_fd_sc_hd__decap_3
Xsky130_fd_sc_hd__decap_8_260 VSUBS VSUBS VSUBS VSUBS sky130_fd_sc_hd__decap_8
Xsky130_fd_sc_hd__decap_8_271 VSUBS VSUBS VSUBS VSUBS sky130_fd_sc_hd__decap_8
Xsky130_fd_sc_hd__nor2_1_48 VSUBS VSUBS VSUBS VSUBS VSUBS VSUBS VSUBS sky130_fd_sc_hd__nor2_1
Xsky130_fd_sc_hd__nor2_1_59 VSUBS VSUBS VSUBS VSUBS VSUBS VSUBS VSUBS sky130_fd_sc_hd__nor2_1
Xsky130_fd_sc_hd__nor2_1_15 VSUBS VSUBS VSUBS VSUBS VSUBS VSUBS VSUBS sky130_fd_sc_hd__nor2_1
Xsky130_fd_sc_hd__nor2_1_26 VSUBS VSUBS VSUBS VSUBS VSUBS VSUBS VSUBS sky130_fd_sc_hd__nor2_1
Xsky130_fd_sc_hd__nor2_1_37 VSUBS VSUBS VSUBS VSUBS VSUBS VSUBS VSUBS sky130_fd_sc_hd__nor2_1
Xsky130_fd_sc_hd__decap_12_519 VSUBS VSUBS VSUBS VSUBS sky130_fd_sc_hd__decap_12
Xsky130_fd_sc_hd__decap_12_508 VSUBS VSUBS VSUBS VSUBS sky130_fd_sc_hd__decap_12
Xsky130_fd_sc_hd__decap_12_316 VSUBS VSUBS VSUBS VSUBS sky130_fd_sc_hd__decap_12
Xsky130_fd_sc_hd__decap_12_305 VSUBS VSUBS VSUBS VSUBS sky130_fd_sc_hd__decap_12
Xsky130_fd_sc_hd__decap_12_338 VSUBS VSUBS VSUBS VSUBS sky130_fd_sc_hd__decap_12
Xsky130_fd_sc_hd__decap_12_349 VSUBS VSUBS VSUBS VSUBS sky130_fd_sc_hd__decap_12
Xsky130_fd_sc_hd__decap_12_327 VSUBS VSUBS VSUBS VSUBS sky130_fd_sc_hd__decap_12
Xsky130_fd_sc_hd__conb_1_10 VSUBS VSUBS VSUBS VSUBS VSUBS VSUBS sky130_fd_sc_hd__conb_1_10/a_21_232#
+ sky130_fd_sc_hd__conb_1_10/a_159_232# sky130_fd_sc_hd__conb_1
Xsky130_fd_sc_hd__decap_12_861 VSUBS VSUBS VSUBS VSUBS sky130_fd_sc_hd__decap_12
Xsky130_fd_sc_hd__decap_12_850 VSUBS VSUBS VSUBS VSUBS sky130_fd_sc_hd__decap_12
Xsky130_fd_sc_hd__decap_12_872 VSUBS VSUBS VSUBS VSUBS sky130_fd_sc_hd__decap_12
Xsky130_fd_sc_hd__decap_12_894 VSUBS VSUBS VSUBS VSUBS sky130_fd_sc_hd__decap_12
Xsky130_fd_sc_hd__decap_12_883 VSUBS VSUBS VSUBS VSUBS sky130_fd_sc_hd__decap_12
Xsky130_fd_sc_hd__nor3b_1_0 VSUBS VSUBS VSUBS VSUBS VSUBS VSUBS VSUBS VSUBS VSUBS
+ sky130_fd_sc_hd__nor3b_1
Xsky130_fd_sc_hd__decap_8_40 VSUBS VSUBS VSUBS VSUBS sky130_fd_sc_hd__decap_8
Xsky130_fd_sc_hd__decap_8_84 VSUBS VSUBS VSUBS VSUBS sky130_fd_sc_hd__decap_8
Xsky130_fd_sc_hd__decap_8_95 VSUBS VSUBS VSUBS VSUBS sky130_fd_sc_hd__decap_8
Xsky130_fd_sc_hd__decap_8_51 VSUBS VSUBS VSUBS VSUBS sky130_fd_sc_hd__decap_8
Xsky130_fd_sc_hd__decap_8_73 VSUBS VSUBS VSUBS VSUBS sky130_fd_sc_hd__decap_8
Xsky130_fd_sc_hd__decap_8_62 VSUBS VSUBS VSUBS VSUBS sky130_fd_sc_hd__decap_8
Xsky130_fd_sc_hd__decap_12_102 VSUBS VSUBS VSUBS VSUBS sky130_fd_sc_hd__decap_12
Xsky130_fd_sc_hd__decap_12_113 VSUBS VSUBS VSUBS VSUBS sky130_fd_sc_hd__decap_12
Xsky130_fd_sc_hd__decap_12_157 VSUBS VSUBS VSUBS VSUBS sky130_fd_sc_hd__decap_12
Xsky130_fd_sc_hd__decap_12_146 VSUBS VSUBS VSUBS VSUBS sky130_fd_sc_hd__decap_12
Xsky130_fd_sc_hd__decap_12_124 VSUBS VSUBS VSUBS VSUBS sky130_fd_sc_hd__decap_12
Xsky130_fd_sc_hd__decap_12_135 VSUBS VSUBS VSUBS VSUBS sky130_fd_sc_hd__decap_12
Xsky130_fd_sc_hd__decap_12_1101 VSUBS VSUBS VSUBS VSUBS sky130_fd_sc_hd__decap_12
Xsky130_fd_sc_hd__decap_12_179 VSUBS VSUBS VSUBS VSUBS sky130_fd_sc_hd__decap_12
Xsky130_fd_sc_hd__decap_12_168 VSUBS VSUBS VSUBS VSUBS sky130_fd_sc_hd__decap_12
Xsky130_fd_sc_hd__decap_12_1112 VSUBS VSUBS VSUBS VSUBS sky130_fd_sc_hd__decap_12
Xsky130_fd_sc_hd__decap_12_1123 VSUBS VSUBS VSUBS VSUBS sky130_fd_sc_hd__decap_12
Xsky130_fd_sc_hd__decap_12_1145 VSUBS VSUBS VSUBS VSUBS sky130_fd_sc_hd__decap_12
Xsky130_fd_sc_hd__decap_12_1134 VSUBS VSUBS VSUBS VSUBS sky130_fd_sc_hd__decap_12
Xsky130_fd_sc_hd__decap_12_1156 VSUBS VSUBS VSUBS VSUBS sky130_fd_sc_hd__decap_12
Xsky130_fd_sc_hd__nand3_1_2 VSUBS VSUBS VSUBS VSUBS VSUBS VSUBS VSUBS VSUBS sky130_fd_sc_hd__nand3_1
Xsky130_fd_sc_hd__decap_12_680 VSUBS VSUBS VSUBS VSUBS sky130_fd_sc_hd__decap_12
Xsky130_fd_sc_hd__decap_12_691 VSUBS VSUBS VSUBS VSUBS sky130_fd_sc_hd__decap_12
Xsky130_fd_sc_hd__decap_12_3 VSUBS VSUBS VSUBS VSUBS sky130_fd_sc_hd__decap_12
Xsky130_fd_sc_hd__decap_4_103 VSUBS VSUBS VSUBS VSUBS sky130_fd_sc_hd__decap_4
Xsky130_fd_sc_hd__decap_8_0 VSUBS VSUBS VSUBS VSUBS sky130_fd_sc_hd__decap_8
Xsky130_fd_sc_hd__decap_3_180 VSUBS VSUBS VSUBS VSUBS sky130_fd_sc_hd__decap_3
Xsky130_fd_sc_hd__decap_3_191 VSUBS VSUBS VSUBS VSUBS sky130_fd_sc_hd__decap_3
Xsky130_fd_sc_hd__o31ai_1_0 VSUBS VSUBS VSUBS VSUBS VSUBS VSUBS VSUBS VSUBS VSUBS
+ VSUBS sky130_fd_sc_hd__o31ai_1
Xsky130_fd_sc_hd__decap_8_250 VSUBS VSUBS VSUBS VSUBS sky130_fd_sc_hd__decap_8
Xsky130_fd_sc_hd__decap_8_261 VSUBS VSUBS VSUBS VSUBS sky130_fd_sc_hd__decap_8
Xsky130_fd_sc_hd__decap_8_272 VSUBS VSUBS VSUBS VSUBS sky130_fd_sc_hd__decap_8
Xsky130_fd_sc_hd__nor2_1_16 VSUBS VSUBS VSUBS VSUBS VSUBS VSUBS VSUBS sky130_fd_sc_hd__nor2_1
Xsky130_fd_sc_hd__nor2_1_49 VSUBS VSUBS VSUBS VSUBS VSUBS VSUBS VSUBS sky130_fd_sc_hd__nor2_1
Xsky130_fd_sc_hd__nor2_1_38 VSUBS VSUBS VSUBS VSUBS VSUBS VSUBS VSUBS sky130_fd_sc_hd__nor2_1
Xsky130_fd_sc_hd__nor2_1_27 VSUBS VSUBS VSUBS VSUBS VSUBS VSUBS VSUBS sky130_fd_sc_hd__nor2_1
Xsky130_fd_sc_hd__decap_12_509 VSUBS VSUBS VSUBS VSUBS sky130_fd_sc_hd__decap_12
Xsky130_fd_sc_hd__decap_12_317 VSUBS VSUBS VSUBS VSUBS sky130_fd_sc_hd__decap_12
Xsky130_fd_sc_hd__decap_12_306 VSUBS VSUBS VSUBS VSUBS sky130_fd_sc_hd__decap_12
Xsky130_fd_sc_hd__decap_12_328 VSUBS VSUBS VSUBS VSUBS sky130_fd_sc_hd__decap_12
Xsky130_fd_sc_hd__decap_12_339 VSUBS VSUBS VSUBS VSUBS sky130_fd_sc_hd__decap_12
Xsky130_fd_sc_hd__conb_1_11 VSUBS VSUBS VSUBS VSUBS VSUBS VSUBS sky130_fd_sc_hd__conb_1_13/a_21_232#
+ sky130_fd_sc_hd__conb_1_13/a_159_232# sky130_fd_sc_hd__conb_1
Xsky130_fd_sc_hd__decap_12_840 VSUBS VSUBS VSUBS VSUBS sky130_fd_sc_hd__decap_12
Xsky130_fd_sc_hd__decap_12_884 VSUBS VSUBS VSUBS VSUBS sky130_fd_sc_hd__decap_12
Xsky130_fd_sc_hd__decap_12_862 VSUBS VSUBS VSUBS VSUBS sky130_fd_sc_hd__decap_12
Xsky130_fd_sc_hd__decap_12_851 VSUBS VSUBS VSUBS VSUBS sky130_fd_sc_hd__decap_12
Xsky130_fd_sc_hd__decap_12_873 VSUBS VSUBS VSUBS VSUBS sky130_fd_sc_hd__decap_12
Xsky130_fd_sc_hd__decap_12_895 VSUBS VSUBS VSUBS VSUBS sky130_fd_sc_hd__decap_12
Xsky130_fd_sc_hd__decap_8_63 VSUBS VSUBS VSUBS VSUBS sky130_fd_sc_hd__decap_8
Xsky130_fd_sc_hd__decap_8_30 VSUBS VSUBS VSUBS VSUBS sky130_fd_sc_hd__decap_8
Xsky130_fd_sc_hd__decap_8_41 VSUBS VSUBS VSUBS VSUBS sky130_fd_sc_hd__decap_8
Xsky130_fd_sc_hd__decap_8_74 VSUBS VSUBS VSUBS VSUBS sky130_fd_sc_hd__decap_8
Xsky130_fd_sc_hd__decap_8_52 VSUBS VSUBS VSUBS VSUBS sky130_fd_sc_hd__decap_8
Xsky130_fd_sc_hd__decap_8_85 VSUBS VSUBS VSUBS VSUBS sky130_fd_sc_hd__decap_8
Xsky130_fd_sc_hd__decap_8_96 VSUBS VSUBS VSUBS VSUBS sky130_fd_sc_hd__decap_8
Xsky130_fd_sc_hd__decap_12_103 VSUBS VSUBS VSUBS VSUBS sky130_fd_sc_hd__decap_12
Xsky130_fd_sc_hd__decap_12_158 VSUBS VSUBS VSUBS VSUBS sky130_fd_sc_hd__decap_12
Xsky130_fd_sc_hd__decap_12_114 VSUBS VSUBS VSUBS VSUBS sky130_fd_sc_hd__decap_12
Xsky130_fd_sc_hd__decap_12_147 VSUBS VSUBS VSUBS VSUBS sky130_fd_sc_hd__decap_12
Xsky130_fd_sc_hd__decap_12_136 VSUBS VSUBS VSUBS VSUBS sky130_fd_sc_hd__decap_12
Xsky130_fd_sc_hd__decap_12_169 VSUBS VSUBS VSUBS VSUBS sky130_fd_sc_hd__decap_12
Xsky130_fd_sc_hd__decap_12_125 VSUBS VSUBS VSUBS VSUBS sky130_fd_sc_hd__decap_12
Xsky130_fd_sc_hd__decap_12_1102 VSUBS VSUBS VSUBS VSUBS sky130_fd_sc_hd__decap_12
Xsky130_fd_sc_hd__decap_12_1113 VSUBS VSUBS VSUBS VSUBS sky130_fd_sc_hd__decap_12
Xsky130_fd_sc_hd__decap_12_1135 VSUBS VSUBS VSUBS VSUBS sky130_fd_sc_hd__decap_12
Xsky130_fd_sc_hd__decap_12_1124 VSUBS VSUBS VSUBS VSUBS sky130_fd_sc_hd__decap_12
Xsky130_fd_sc_hd__decap_12_1146 VSUBS VSUBS VSUBS VSUBS sky130_fd_sc_hd__decap_12
Xsky130_fd_sc_hd__decap_12_1157 VSUBS VSUBS VSUBS VSUBS sky130_fd_sc_hd__decap_12
Xsky130_fd_sc_hd__nand3_1_3 VSUBS VSUBS VSUBS VSUBS VSUBS VSUBS VSUBS sky130_fd_sc_hd__nand3_1_3/C
+ sky130_fd_sc_hd__nand3_1
Xsky130_fd_sc_hd__decap_12_670 VSUBS VSUBS VSUBS VSUBS sky130_fd_sc_hd__decap_12
Xsky130_fd_sc_hd__decap_12_692 VSUBS VSUBS VSUBS VSUBS sky130_fd_sc_hd__decap_12
Xsky130_fd_sc_hd__decap_12_681 VSUBS VSUBS VSUBS VSUBS sky130_fd_sc_hd__decap_12
Xsky130_fd_sc_hd__clkbuf_16_0 VSUBS VSUBS VSUBS VSUBS VSUBS VSUBS VSUBS sky130_fd_sc_hd__clkbuf_16
Xsky130_fd_sc_hd__decap_12_4 VSUBS VSUBS VSUBS VSUBS sky130_fd_sc_hd__decap_12
Xsky130_fd_sc_hd__nor4_1_0 VSUBS VSUBS VSUBS VSUBS VSUBS VSUBS VSUBS VSUBS VSUBS sky130_fd_sc_hd__nor4_1
Xsky130_fd_sc_hd__decap_4_104 VSUBS VSUBS VSUBS VSUBS sky130_fd_sc_hd__decap_4
Xsky130_fd_sc_hd__decap_8_1 VSUBS VSUBS VSUBS VSUBS sky130_fd_sc_hd__decap_8
Xsky130_fd_sc_hd__decap_3_192 VSUBS VSUBS VSUBS VSUBS sky130_fd_sc_hd__decap_3
Xsky130_fd_sc_hd__decap_3_181 VSUBS VSUBS VSUBS VSUBS sky130_fd_sc_hd__decap_3
Xsky130_fd_sc_hd__decap_3_170 VSUBS VSUBS VSUBS VSUBS sky130_fd_sc_hd__decap_3
Xsky130_fd_sc_hd__decap_8_251 VSUBS VSUBS VSUBS VSUBS sky130_fd_sc_hd__decap_8
Xsky130_fd_sc_hd__decap_8_240 VSUBS VSUBS VSUBS VSUBS sky130_fd_sc_hd__decap_8
Xsky130_fd_sc_hd__decap_8_262 VSUBS VSUBS VSUBS VSUBS sky130_fd_sc_hd__decap_8
Xsky130_fd_sc_hd__decap_8_273 VSUBS VSUBS VSUBS VSUBS sky130_fd_sc_hd__decap_8
Xsky130_fd_sc_hd__nor2_1_39 VSUBS VSUBS VSUBS VSUBS VSUBS VSUBS VSUBS sky130_fd_sc_hd__nor2_1
Xsky130_fd_sc_hd__nor2_1_17 VSUBS VSUBS VSUBS VSUBS VSUBS VSUBS VSUBS sky130_fd_sc_hd__nor2_1
Xsky130_fd_sc_hd__nor2_1_28 VSUBS VSUBS VSUBS VSUBS VSUBS VSUBS VSUBS sky130_fd_sc_hd__nor2_1
Xsky130_fd_sc_hd__decap_12_307 VSUBS VSUBS VSUBS VSUBS sky130_fd_sc_hd__decap_12
Xsky130_fd_sc_hd__decap_12_318 VSUBS VSUBS VSUBS VSUBS sky130_fd_sc_hd__decap_12
Xsky130_fd_sc_hd__decap_12_329 VSUBS VSUBS VSUBS VSUBS sky130_fd_sc_hd__decap_12
Xsky130_fd_sc_hd__conb_1_12 VSUBS VSUBS VSUBS VSUBS VSUBS VSUBS sky130_fd_sc_hd__conb_1_12/a_21_232#
+ sky130_fd_sc_hd__conb_1_12/a_159_232# sky130_fd_sc_hd__conb_1
Xsky130_fd_sc_hd__decap_12_841 VSUBS VSUBS VSUBS VSUBS sky130_fd_sc_hd__decap_12
Xsky130_fd_sc_hd__decap_12_830 VSUBS VSUBS VSUBS VSUBS sky130_fd_sc_hd__decap_12
Xsky130_fd_sc_hd__decap_12_852 VSUBS VSUBS VSUBS VSUBS sky130_fd_sc_hd__decap_12
Xsky130_fd_sc_hd__decap_12_874 VSUBS VSUBS VSUBS VSUBS sky130_fd_sc_hd__decap_12
Xsky130_fd_sc_hd__decap_12_885 VSUBS VSUBS VSUBS VSUBS sky130_fd_sc_hd__decap_12
Xsky130_fd_sc_hd__decap_12_863 VSUBS VSUBS VSUBS VSUBS sky130_fd_sc_hd__decap_12
Xsky130_fd_sc_hd__decap_12_896 VSUBS VSUBS VSUBS VSUBS sky130_fd_sc_hd__decap_12
Xsky130_fd_sc_hd__a2bb2oi_1_0 VSUBS VSUBS VSUBS VSUBS VSUBS VSUBS VSUBS VSUBS VSUBS
+ VSUBS VSUBS sky130_fd_sc_hd__a2bb2oi_1
Xsky130_fd_sc_hd__decap_8_86 VSUBS VSUBS VSUBS VSUBS sky130_fd_sc_hd__decap_8
Xsky130_fd_sc_hd__decap_8_97 VSUBS VSUBS VSUBS VSUBS sky130_fd_sc_hd__decap_8
Xsky130_fd_sc_hd__decap_8_31 VSUBS VSUBS VSUBS VSUBS sky130_fd_sc_hd__decap_8
Xsky130_fd_sc_hd__decap_8_20 VSUBS VSUBS VSUBS VSUBS sky130_fd_sc_hd__decap_8
Xsky130_fd_sc_hd__decap_8_75 VSUBS VSUBS VSUBS VSUBS sky130_fd_sc_hd__decap_8
Xsky130_fd_sc_hd__decap_8_42 VSUBS VSUBS VSUBS VSUBS sky130_fd_sc_hd__decap_8
Xsky130_fd_sc_hd__decap_8_53 VSUBS VSUBS VSUBS VSUBS sky130_fd_sc_hd__decap_8
Xsky130_fd_sc_hd__decap_8_64 VSUBS VSUBS VSUBS VSUBS sky130_fd_sc_hd__decap_8
Xsky130_fd_sc_hd__decap_12_104 VSUBS VSUBS VSUBS VSUBS sky130_fd_sc_hd__decap_12
Xsky130_fd_sc_hd__decap_12_159 VSUBS VSUBS VSUBS VSUBS sky130_fd_sc_hd__decap_12
Xsky130_fd_sc_hd__decap_12_115 VSUBS VSUBS VSUBS VSUBS sky130_fd_sc_hd__decap_12
Xsky130_fd_sc_hd__decap_12_148 VSUBS VSUBS VSUBS VSUBS sky130_fd_sc_hd__decap_12
Xsky130_fd_sc_hd__decap_12_137 VSUBS VSUBS VSUBS VSUBS sky130_fd_sc_hd__decap_12
Xsky130_fd_sc_hd__decap_12_126 VSUBS VSUBS VSUBS VSUBS sky130_fd_sc_hd__decap_12
Xsky130_fd_sc_hd__decap_12_1136 VSUBS VSUBS VSUBS VSUBS sky130_fd_sc_hd__decap_12
Xsky130_fd_sc_hd__decap_12_1125 VSUBS VSUBS VSUBS VSUBS sky130_fd_sc_hd__decap_12
Xsky130_fd_sc_hd__decap_12_1147 VSUBS VSUBS VSUBS VSUBS sky130_fd_sc_hd__decap_12
Xsky130_fd_sc_hd__decap_12_1114 VSUBS VSUBS VSUBS VSUBS sky130_fd_sc_hd__decap_12
Xsky130_fd_sc_hd__decap_12_1103 VSUBS VSUBS VSUBS VSUBS sky130_fd_sc_hd__decap_12
Xsky130_fd_sc_hd__decap_12_1158 VSUBS VSUBS VSUBS VSUBS sky130_fd_sc_hd__decap_12
Xsky130_fd_sc_hd__nand3_1_4 VSUBS VSUBS VSUBS VSUBS VSUBS VSUBS VSUBS VSUBS sky130_fd_sc_hd__nand3_1
Xsky130_fd_sc_hd__xnor2_1_20 VSUBS VSUBS VSUBS VSUBS VSUBS VSUBS VSUBS VSUBS VSUBS
+ sky130_fd_sc_hd__xnor2_1_20/a_377_297# sky130_fd_sc_hd__xnor2_1
Xsky130_fd_sc_hd__decap_12_671 VSUBS VSUBS VSUBS VSUBS sky130_fd_sc_hd__decap_12
Xsky130_fd_sc_hd__decap_12_660 VSUBS VSUBS VSUBS VSUBS sky130_fd_sc_hd__decap_12
Xsky130_fd_sc_hd__decap_12_682 VSUBS VSUBS VSUBS VSUBS sky130_fd_sc_hd__decap_12
Xsky130_fd_sc_hd__decap_12_693 VSUBS VSUBS VSUBS VSUBS sky130_fd_sc_hd__decap_12
Xsky130_fd_sc_hd__a211oi_1_0 VSUBS VSUBS VSUBS VSUBS VSUBS VSUBS VSUBS VSUBS VSUBS
+ VSUBS sky130_fd_sc_hd__a211oi_1
Xsky130_fd_sc_hd__clkbuf_16_1 VSUBS VSUBS VSUBS VSUBS VSUBS VSUBS VSUBS sky130_fd_sc_hd__clkbuf_16
Xsky130_fd_sc_hd__nor4_1_1 VSUBS VSUBS VSUBS VSUBS VSUBS VSUBS VSUBS VSUBS VSUBS sky130_fd_sc_hd__nor4_1
Xsky130_fd_sc_hd__a22oi_1_0 VSUBS VSUBS VSUBS VSUBS VSUBS VSUBS VSUBS VSUBS VSUBS
+ sky130_fd_sc_hd__a22oi_1_0/a_381_47# VSUBS sky130_fd_sc_hd__a22oi_1
Xsky130_fd_sc_hd__decap_12_5 VSUBS VSUBS VSUBS VSUBS sky130_fd_sc_hd__decap_12
Xsky130_fd_sc_hd__decap_12_490 VSUBS VSUBS VSUBS VSUBS sky130_fd_sc_hd__decap_12
Xsky130_fd_sc_hd__decap_8_2 VSUBS VSUBS VSUBS VSUBS sky130_fd_sc_hd__decap_8
Xsky130_fd_sc_hd__decap_3_193 VSUBS VSUBS VSUBS VSUBS sky130_fd_sc_hd__decap_3
Xsky130_fd_sc_hd__decap_3_171 VSUBS VSUBS VSUBS VSUBS sky130_fd_sc_hd__decap_3
Xsky130_fd_sc_hd__decap_3_182 VSUBS VSUBS VSUBS VSUBS sky130_fd_sc_hd__decap_3
Xsky130_fd_sc_hd__decap_3_160 VSUBS VSUBS VSUBS VSUBS sky130_fd_sc_hd__decap_3
Xsky130_fd_sc_hd__decap_8_252 VSUBS VSUBS VSUBS VSUBS sky130_fd_sc_hd__decap_8
Xsky130_fd_sc_hd__decap_8_230 VSUBS VSUBS VSUBS VSUBS sky130_fd_sc_hd__decap_8
Xsky130_fd_sc_hd__decap_8_241 VSUBS VSUBS VSUBS VSUBS sky130_fd_sc_hd__decap_8
Xsky130_fd_sc_hd__decap_8_263 VSUBS VSUBS VSUBS VSUBS sky130_fd_sc_hd__decap_8
Xsky130_fd_sc_hd__decap_8_274 VSUBS VSUBS VSUBS VSUBS sky130_fd_sc_hd__decap_8
Xsky130_fd_sc_hd__nor2_1_29 VSUBS VSUBS VSUBS VSUBS VSUBS VSUBS VSUBS sky130_fd_sc_hd__nor2_1
Xsky130_fd_sc_hd__nor2_1_18 VSUBS VSUBS VSUBS VSUBS VSUBS VSUBS VSUBS sky130_fd_sc_hd__nor2_1
Xsky130_fd_sc_hd__decap_12_308 VSUBS VSUBS VSUBS VSUBS sky130_fd_sc_hd__decap_12
Xsky130_fd_sc_hd__decap_12_319 VSUBS VSUBS VSUBS VSUBS sky130_fd_sc_hd__decap_12
Xsky130_fd_sc_hd__conb_1_13 VSUBS VSUBS VSUBS VSUBS VSUBS VSUBS sky130_fd_sc_hd__conb_1_13/a_21_232#
+ sky130_fd_sc_hd__conb_1_13/a_159_232# sky130_fd_sc_hd__conb_1
Xsky130_fd_sc_hd__decap_12_820 VSUBS VSUBS VSUBS VSUBS sky130_fd_sc_hd__decap_12
Xsky130_fd_sc_hd__decap_12_842 VSUBS VSUBS VSUBS VSUBS sky130_fd_sc_hd__decap_12
Xsky130_fd_sc_hd__decap_12_831 VSUBS VSUBS VSUBS VSUBS sky130_fd_sc_hd__decap_12
Xsky130_fd_sc_hd__a2bb2oi_1_1 VSUBS VSUBS VSUBS VSUBS VSUBS VSUBS VSUBS VSUBS VSUBS
+ VSUBS VSUBS sky130_fd_sc_hd__a2bb2oi_1
Xsky130_fd_sc_hd__decap_12_864 VSUBS VSUBS VSUBS VSUBS sky130_fd_sc_hd__decap_12
Xsky130_fd_sc_hd__decap_12_853 VSUBS VSUBS VSUBS VSUBS sky130_fd_sc_hd__decap_12
Xsky130_fd_sc_hd__decap_12_897 VSUBS VSUBS VSUBS VSUBS sky130_fd_sc_hd__decap_12
Xsky130_fd_sc_hd__decap_12_875 VSUBS VSUBS VSUBS VSUBS sky130_fd_sc_hd__decap_12
Xsky130_fd_sc_hd__decap_12_886 VSUBS VSUBS VSUBS VSUBS sky130_fd_sc_hd__decap_12
Xsky130_fd_sc_hd__decap_8_65 VSUBS VSUBS VSUBS VSUBS sky130_fd_sc_hd__decap_8
Xsky130_fd_sc_hd__decap_8_98 VSUBS VSUBS VSUBS VSUBS sky130_fd_sc_hd__decap_8
Xsky130_fd_sc_hd__decap_8_10 VSUBS VSUBS VSUBS VSUBS sky130_fd_sc_hd__decap_8
Xsky130_fd_sc_hd__decap_8_76 VSUBS VSUBS VSUBS VSUBS sky130_fd_sc_hd__decap_8
Xsky130_fd_sc_hd__decap_8_87 VSUBS VSUBS VSUBS VSUBS sky130_fd_sc_hd__decap_8
Xsky130_fd_sc_hd__decap_8_21 VSUBS VSUBS VSUBS VSUBS sky130_fd_sc_hd__decap_8
Xsky130_fd_sc_hd__decap_8_32 VSUBS VSUBS VSUBS VSUBS sky130_fd_sc_hd__decap_8
Xsky130_fd_sc_hd__decap_8_54 VSUBS VSUBS VSUBS VSUBS sky130_fd_sc_hd__decap_8
Xsky130_fd_sc_hd__decap_8_43 VSUBS VSUBS VSUBS VSUBS sky130_fd_sc_hd__decap_8
Xsky130_fd_sc_hd__decap_12_105 VSUBS VSUBS VSUBS VSUBS sky130_fd_sc_hd__decap_12
Xsky130_fd_sc_hd__decap_12_116 VSUBS VSUBS VSUBS VSUBS sky130_fd_sc_hd__decap_12
Xsky130_fd_sc_hd__decap_12_149 VSUBS VSUBS VSUBS VSUBS sky130_fd_sc_hd__decap_12
Xsky130_fd_sc_hd__decap_12_127 VSUBS VSUBS VSUBS VSUBS sky130_fd_sc_hd__decap_12
Xsky130_fd_sc_hd__decap_12_138 VSUBS VSUBS VSUBS VSUBS sky130_fd_sc_hd__decap_12
Xsky130_fd_sc_hd__decap_12_1104 VSUBS VSUBS VSUBS VSUBS sky130_fd_sc_hd__decap_12
Xsky130_fd_sc_hd__nand3_1_5 VSUBS VSUBS VSUBS VSUBS VSUBS VSUBS VSUBS VSUBS sky130_fd_sc_hd__nand3_1
Xsky130_fd_sc_hd__decap_12_1137 VSUBS VSUBS VSUBS VSUBS sky130_fd_sc_hd__decap_12
Xsky130_fd_sc_hd__decap_12_1126 VSUBS VSUBS VSUBS VSUBS sky130_fd_sc_hd__decap_12
Xsky130_fd_sc_hd__decap_12_1148 VSUBS VSUBS VSUBS VSUBS sky130_fd_sc_hd__decap_12
Xsky130_fd_sc_hd__decap_12_1115 VSUBS VSUBS VSUBS VSUBS sky130_fd_sc_hd__decap_12
Xsky130_fd_sc_hd__decap_12_1159 VSUBS VSUBS VSUBS VSUBS sky130_fd_sc_hd__decap_12
Xsky130_fd_sc_hd__xnor2_1_21 VSUBS VSUBS VSUBS VSUBS VSUBS VSUBS VSUBS VSUBS VSUBS
+ sky130_fd_sc_hd__xnor2_1_21/a_377_297# sky130_fd_sc_hd__xnor2_1
Xsky130_fd_sc_hd__xnor2_1_10 VSUBS VSUBS VSUBS VSUBS VSUBS VSUBS VSUBS VSUBS VSUBS
+ sky130_fd_sc_hd__xnor2_1_10/a_377_297# sky130_fd_sc_hd__xnor2_1
Xsky130_fd_sc_hd__decap_12_650 VSUBS VSUBS VSUBS VSUBS sky130_fd_sc_hd__decap_12
Xsky130_fd_sc_hd__decap_12_661 VSUBS VSUBS VSUBS VSUBS sky130_fd_sc_hd__decap_12
Xsky130_fd_sc_hd__decap_12_683 VSUBS VSUBS VSUBS VSUBS sky130_fd_sc_hd__decap_12
Xsky130_fd_sc_hd__decap_12_672 VSUBS VSUBS VSUBS VSUBS sky130_fd_sc_hd__decap_12
Xsky130_fd_sc_hd__decap_12_694 VSUBS VSUBS VSUBS VSUBS sky130_fd_sc_hd__decap_12
Xsky130_fd_sc_hd__a211oi_1_1 VSUBS VSUBS VSUBS VSUBS VSUBS sky130_fd_sc_hd__a211oi_1_1/C1
+ sky130_fd_sc_hd__a211oi_1_1/B1 VSUBS VSUBS VSUBS sky130_fd_sc_hd__a211oi_1
Xsky130_fd_sc_hd__nor4_1_2 VSUBS VSUBS VSUBS VSUBS VSUBS VSUBS VSUBS VSUBS VSUBS sky130_fd_sc_hd__nor4_1
Xsky130_fd_sc_hd__a22oi_1_1 VSUBS VSUBS VSUBS VSUBS VSUBS VSUBS VSUBS VSUBS VSUBS
+ sky130_fd_sc_hd__a22oi_1_1/a_381_47# VSUBS sky130_fd_sc_hd__a22oi_1
Xsky130_fd_sc_hd__clkbuf_16_2 VSUBS VSUBS VSUBS VSUBS VSUBS VSUBS VSUBS sky130_fd_sc_hd__clkbuf_16
Xsky130_fd_sc_hd__decap_12_6 VSUBS VSUBS VSUBS VSUBS sky130_fd_sc_hd__decap_12
Xsky130_fd_sc_hd__decap_12_491 VSUBS VSUBS VSUBS VSUBS sky130_fd_sc_hd__decap_12
Xsky130_fd_sc_hd__decap_12_480 VSUBS VSUBS VSUBS VSUBS sky130_fd_sc_hd__decap_12
Xsky130_fd_sc_hd__decap_8_3 VSUBS VSUBS VSUBS VSUBS sky130_fd_sc_hd__decap_8
Xsky130_fd_sc_hd__decap_3_150 VSUBS VSUBS VSUBS VSUBS sky130_fd_sc_hd__decap_3
Xsky130_fd_sc_hd__decap_3_161 VSUBS VSUBS VSUBS VSUBS sky130_fd_sc_hd__decap_3
Xsky130_fd_sc_hd__decap_3_172 VSUBS VSUBS VSUBS VSUBS sky130_fd_sc_hd__decap_3
Xsky130_fd_sc_hd__decap_3_194 VSUBS VSUBS VSUBS VSUBS sky130_fd_sc_hd__decap_3
Xsky130_fd_sc_hd__decap_3_183 VSUBS VSUBS VSUBS VSUBS sky130_fd_sc_hd__decap_3
Xsky130_fd_sc_hd__a21oi_1_0 VSUBS VSUBS VSUBS VSUBS VSUBS VSUBS VSUBS VSUBS VSUBS
+ sky130_fd_sc_hd__a21oi_1
Xsky130_fd_sc_hd__decap_6_0 VSUBS VSUBS VSUBS VSUBS sky130_fd_sc_hd__decap_6
Xsky130_fd_sc_hd__decap_8_253 VSUBS VSUBS VSUBS VSUBS sky130_fd_sc_hd__decap_8
Xsky130_fd_sc_hd__decap_8_231 VSUBS VSUBS VSUBS VSUBS sky130_fd_sc_hd__decap_8
Xsky130_fd_sc_hd__decap_8_242 VSUBS VSUBS VSUBS VSUBS sky130_fd_sc_hd__decap_8
Xsky130_fd_sc_hd__decap_8_220 VSUBS VSUBS VSUBS VSUBS sky130_fd_sc_hd__decap_8
Xsky130_fd_sc_hd__decap_8_264 VSUBS VSUBS VSUBS VSUBS sky130_fd_sc_hd__decap_8
Xsky130_fd_sc_hd__decap_8_275 VSUBS VSUBS VSUBS VSUBS sky130_fd_sc_hd__decap_8
Xsky130_fd_sc_hd__nor2_1_19 VSUBS VSUBS VSUBS VSUBS VSUBS VSUBS VSUBS sky130_fd_sc_hd__nor2_1
Xsky130_fd_sc_hd__decap_12_309 VSUBS VSUBS VSUBS VSUBS sky130_fd_sc_hd__decap_12
Xsky130_fd_sc_hd__conb_1_14 VSUBS VSUBS VSUBS VSUBS VSUBS VSUBS sky130_fd_sc_hd__conb_1_14/a_21_232#
+ sky130_fd_sc_hd__conb_1_14/a_159_232# sky130_fd_sc_hd__conb_1
Xsky130_fd_sc_hd__decap_12_832 VSUBS VSUBS VSUBS VSUBS sky130_fd_sc_hd__decap_12
Xsky130_fd_sc_hd__decap_12_843 VSUBS VSUBS VSUBS VSUBS sky130_fd_sc_hd__decap_12
Xsky130_fd_sc_hd__decap_12_854 VSUBS VSUBS VSUBS VSUBS sky130_fd_sc_hd__decap_12
Xsky130_fd_sc_hd__decap_12_810 VSUBS VSUBS VSUBS VSUBS sky130_fd_sc_hd__decap_12
Xsky130_fd_sc_hd__decap_12_821 VSUBS VSUBS VSUBS VSUBS sky130_fd_sc_hd__decap_12
Xsky130_fd_sc_hd__decap_12_887 VSUBS VSUBS VSUBS VSUBS sky130_fd_sc_hd__decap_12
Xsky130_fd_sc_hd__decap_12_865 VSUBS VSUBS VSUBS VSUBS sky130_fd_sc_hd__decap_12
Xsky130_fd_sc_hd__decap_12_876 VSUBS VSUBS VSUBS VSUBS sky130_fd_sc_hd__decap_12
Xsky130_fd_sc_hd__decap_12_898 VSUBS VSUBS VSUBS VSUBS sky130_fd_sc_hd__decap_12
Xsky130_fd_sc_hd__decap_8_11 VSUBS VSUBS VSUBS VSUBS sky130_fd_sc_hd__decap_8
Xsky130_fd_sc_hd__decap_8_22 VSUBS VSUBS VSUBS VSUBS sky130_fd_sc_hd__decap_8
Xsky130_fd_sc_hd__decap_8_99 VSUBS VSUBS VSUBS VSUBS sky130_fd_sc_hd__decap_8
Xsky130_fd_sc_hd__decap_8_77 VSUBS VSUBS VSUBS VSUBS sky130_fd_sc_hd__decap_8
Xsky130_fd_sc_hd__decap_8_88 VSUBS VSUBS VSUBS VSUBS sky130_fd_sc_hd__decap_8
Xsky130_fd_sc_hd__decap_8_33 VSUBS VSUBS VSUBS VSUBS sky130_fd_sc_hd__decap_8
Xsky130_fd_sc_hd__decap_8_55 VSUBS VSUBS VSUBS VSUBS sky130_fd_sc_hd__decap_8
Xsky130_fd_sc_hd__decap_8_44 VSUBS VSUBS VSUBS VSUBS sky130_fd_sc_hd__decap_8
Xsky130_fd_sc_hd__decap_8_66 VSUBS VSUBS VSUBS VSUBS sky130_fd_sc_hd__decap_8
Xsky130_fd_sc_hd__decap_12_106 VSUBS VSUBS VSUBS VSUBS sky130_fd_sc_hd__decap_12
Xsky130_fd_sc_hd__decap_12_117 VSUBS VSUBS VSUBS VSUBS sky130_fd_sc_hd__decap_12
Xsky130_fd_sc_hd__decap_12_139 VSUBS VSUBS VSUBS VSUBS sky130_fd_sc_hd__decap_12
Xsky130_fd_sc_hd__decap_12_128 VSUBS VSUBS VSUBS VSUBS sky130_fd_sc_hd__decap_12
Xsky130_fd_sc_hd__decap_12_1105 VSUBS VSUBS VSUBS VSUBS sky130_fd_sc_hd__decap_12
Xsky130_fd_sc_hd__decap_12_1138 VSUBS VSUBS VSUBS VSUBS sky130_fd_sc_hd__decap_12
Xsky130_fd_sc_hd__decap_12_1127 VSUBS VSUBS VSUBS VSUBS sky130_fd_sc_hd__decap_12
Xsky130_fd_sc_hd__decap_12_1116 VSUBS VSUBS VSUBS VSUBS sky130_fd_sc_hd__decap_12
Xsky130_fd_sc_hd__decap_12_1149 VSUBS VSUBS VSUBS VSUBS sky130_fd_sc_hd__decap_12
Xsky130_fd_sc_hd__nand3_1_6 VSUBS VSUBS VSUBS VSUBS VSUBS VSUBS VSUBS VSUBS sky130_fd_sc_hd__nand3_1
Xsky130_fd_sc_hd__xnor2_1_22 VSUBS VSUBS VSUBS VSUBS VSUBS VSUBS VSUBS VSUBS VSUBS
+ sky130_fd_sc_hd__xnor2_1_22/a_377_297# sky130_fd_sc_hd__xnor2_1
Xsky130_fd_sc_hd__xnor2_1_11 VSUBS VSUBS VSUBS VSUBS VSUBS VSUBS VSUBS VSUBS VSUBS
+ sky130_fd_sc_hd__xnor2_1_11/a_377_297# sky130_fd_sc_hd__xnor2_1
Xsky130_fd_sc_hd__decap_12_651 VSUBS VSUBS VSUBS VSUBS sky130_fd_sc_hd__decap_12
Xsky130_fd_sc_hd__decap_12_662 VSUBS VSUBS VSUBS VSUBS sky130_fd_sc_hd__decap_12
Xsky130_fd_sc_hd__decap_12_673 VSUBS VSUBS VSUBS VSUBS sky130_fd_sc_hd__decap_12
Xsky130_fd_sc_hd__decap_12_684 VSUBS VSUBS VSUBS VSUBS sky130_fd_sc_hd__decap_12
Xsky130_fd_sc_hd__decap_12_640 VSUBS VSUBS VSUBS VSUBS sky130_fd_sc_hd__decap_12
Xsky130_fd_sc_hd__decap_12_695 VSUBS VSUBS VSUBS VSUBS sky130_fd_sc_hd__decap_12
Xsky130_fd_sc_hd__a211oi_1_2 VSUBS VSUBS VSUBS VSUBS VSUBS VSUBS VSUBS VSUBS VSUBS
+ VSUBS sky130_fd_sc_hd__a211oi_1
Xsky130_fd_sc_hd__nor4_1_3 VSUBS VSUBS VSUBS VSUBS VSUBS sky130_fd_sc_hd__nor4_1_3/D
+ VSUBS VSUBS VSUBS sky130_fd_sc_hd__nor4_1
Xsky130_fd_sc_hd__a22oi_1_2 VSUBS VSUBS VSUBS VSUBS VSUBS VSUBS VSUBS VSUBS VSUBS
+ sky130_fd_sc_hd__a22oi_1_2/a_381_47# VSUBS sky130_fd_sc_hd__a22oi_1
Xsky130_fd_sc_hd__clkbuf_16_3 VSUBS VSUBS VSUBS VSUBS VSUBS VSUBS VSUBS sky130_fd_sc_hd__clkbuf_16
Xsky130_fd_sc_hd__decap_12_7 VSUBS VSUBS VSUBS VSUBS sky130_fd_sc_hd__decap_12
Xsky130_fd_sc_hd__decap_12_481 VSUBS VSUBS VSUBS VSUBS sky130_fd_sc_hd__decap_12
Xsky130_fd_sc_hd__decap_12_470 VSUBS VSUBS VSUBS VSUBS sky130_fd_sc_hd__decap_12
Xsky130_fd_sc_hd__decap_12_492 VSUBS VSUBS VSUBS VSUBS sky130_fd_sc_hd__decap_12
Xsky130_fd_sc_hd__or4b_1_0 VSUBS VSUBS VSUBS VSUBS VSUBS VSUBS VSUBS VSUBS VSUBS VSUBS
+ VSUBS sky130_fd_sc_hd__or4b_1
Xsky130_fd_sc_hd__decap_8_4 VSUBS VSUBS VSUBS VSUBS sky130_fd_sc_hd__decap_8
Xsky130_fd_sc_hd__decap_3_173 VSUBS VSUBS VSUBS VSUBS sky130_fd_sc_hd__decap_3
Xsky130_fd_sc_hd__decap_3_184 VSUBS VSUBS VSUBS VSUBS sky130_fd_sc_hd__decap_3
Xsky130_fd_sc_hd__decap_3_140 VSUBS VSUBS VSUBS VSUBS sky130_fd_sc_hd__decap_3
Xsky130_fd_sc_hd__decap_3_195 VSUBS VSUBS VSUBS VSUBS sky130_fd_sc_hd__decap_3
Xsky130_fd_sc_hd__decap_3_162 VSUBS VSUBS VSUBS VSUBS sky130_fd_sc_hd__decap_3
Xsky130_fd_sc_hd__decap_3_151 VSUBS VSUBS VSUBS VSUBS sky130_fd_sc_hd__decap_3
Xsky130_fd_sc_hd__a21oi_1_1 VSUBS VSUBS VSUBS VSUBS VSUBS VSUBS VSUBS VSUBS VSUBS
+ sky130_fd_sc_hd__a21oi_1
Xsky130_fd_sc_hd__decap_6_1 VSUBS VSUBS VSUBS VSUBS sky130_fd_sc_hd__decap_6
Xsky130_fd_sc_hd__decap_8_254 VSUBS VSUBS VSUBS VSUBS sky130_fd_sc_hd__decap_8
Xsky130_fd_sc_hd__decap_8_232 VSUBS VSUBS VSUBS VSUBS sky130_fd_sc_hd__decap_8
Xsky130_fd_sc_hd__decap_8_243 VSUBS VSUBS VSUBS VSUBS sky130_fd_sc_hd__decap_8
Xsky130_fd_sc_hd__decap_8_221 VSUBS VSUBS VSUBS VSUBS sky130_fd_sc_hd__decap_8
Xsky130_fd_sc_hd__decap_8_210 VSUBS VSUBS VSUBS VSUBS sky130_fd_sc_hd__decap_8
Xsky130_fd_sc_hd__decap_8_265 VSUBS VSUBS VSUBS VSUBS sky130_fd_sc_hd__decap_8
Xsky130_fd_sc_hd__decap_8_276 VSUBS VSUBS VSUBS VSUBS sky130_fd_sc_hd__decap_8
Xsky130_fd_sc_hd__conb_1_15 VSUBS VSUBS VSUBS VSUBS VSUBS VSUBS sky130_fd_sc_hd__conb_1_15/a_21_232#
+ sky130_fd_sc_hd__conb_1_15/a_159_232# sky130_fd_sc_hd__conb_1
Xsky130_fd_sc_hd__decap_12_844 VSUBS VSUBS VSUBS VSUBS sky130_fd_sc_hd__decap_12
Xsky130_fd_sc_hd__decap_12_855 VSUBS VSUBS VSUBS VSUBS sky130_fd_sc_hd__decap_12
Xsky130_fd_sc_hd__decap_12_833 VSUBS VSUBS VSUBS VSUBS sky130_fd_sc_hd__decap_12
Xsky130_fd_sc_hd__decap_12_811 VSUBS VSUBS VSUBS VSUBS sky130_fd_sc_hd__decap_12
Xsky130_fd_sc_hd__decap_12_822 VSUBS VSUBS VSUBS VSUBS sky130_fd_sc_hd__decap_12
Xsky130_fd_sc_hd__decap_12_800 VSUBS VSUBS VSUBS VSUBS sky130_fd_sc_hd__decap_12
Xsky130_fd_sc_hd__decap_12_866 VSUBS VSUBS VSUBS VSUBS sky130_fd_sc_hd__decap_12
Xsky130_fd_sc_hd__decap_12_877 VSUBS VSUBS VSUBS VSUBS sky130_fd_sc_hd__decap_12
Xsky130_fd_sc_hd__decap_12_888 VSUBS VSUBS VSUBS VSUBS sky130_fd_sc_hd__decap_12
Xsky130_fd_sc_hd__decap_12_899 VSUBS VSUBS VSUBS VSUBS sky130_fd_sc_hd__decap_12
Xsky130_fd_sc_hd__decap_8_12 VSUBS VSUBS VSUBS VSUBS sky130_fd_sc_hd__decap_8
Xsky130_fd_sc_hd__decap_8_34 VSUBS VSUBS VSUBS VSUBS sky130_fd_sc_hd__decap_8
Xsky130_fd_sc_hd__decap_8_23 VSUBS VSUBS VSUBS VSUBS sky130_fd_sc_hd__decap_8
Xsky130_fd_sc_hd__decap_8_56 VSUBS VSUBS VSUBS VSUBS sky130_fd_sc_hd__decap_8
Xsky130_fd_sc_hd__decap_8_45 VSUBS VSUBS VSUBS VSUBS sky130_fd_sc_hd__decap_8
Xsky130_fd_sc_hd__decap_8_78 VSUBS VSUBS VSUBS VSUBS sky130_fd_sc_hd__decap_8
Xsky130_fd_sc_hd__decap_8_89 VSUBS VSUBS VSUBS VSUBS sky130_fd_sc_hd__decap_8
Xsky130_fd_sc_hd__decap_8_67 VSUBS VSUBS VSUBS VSUBS sky130_fd_sc_hd__decap_8
Xsky130_fd_sc_hd__decap_12_107 VSUBS VSUBS VSUBS VSUBS sky130_fd_sc_hd__decap_12
Xsky130_fd_sc_hd__decap_12_118 VSUBS VSUBS VSUBS VSUBS sky130_fd_sc_hd__decap_12
Xsky130_fd_sc_hd__decap_12_129 VSUBS VSUBS VSUBS VSUBS sky130_fd_sc_hd__decap_12
Xsky130_fd_sc_hd__decap_12_1106 VSUBS VSUBS VSUBS VSUBS sky130_fd_sc_hd__decap_12
Xsky130_fd_sc_hd__decap_12_1117 VSUBS VSUBS VSUBS VSUBS sky130_fd_sc_hd__decap_12
Xsky130_fd_sc_hd__nand3_1_7 VSUBS VSUBS VSUBS VSUBS VSUBS VSUBS VSUBS VSUBS sky130_fd_sc_hd__nand3_1
Xsky130_fd_sc_hd__decap_12_1128 VSUBS VSUBS VSUBS VSUBS sky130_fd_sc_hd__decap_12
Xsky130_fd_sc_hd__decap_12_1139 VSUBS VSUBS VSUBS VSUBS sky130_fd_sc_hd__decap_12
Xsky130_fd_sc_hd__xnor2_1_23 VSUBS VSUBS VSUBS VSUBS VSUBS VSUBS VSUBS VSUBS VSUBS
+ sky130_fd_sc_hd__xnor2_1_23/a_377_297# sky130_fd_sc_hd__xnor2_1
Xsky130_fd_sc_hd__xnor2_1_12 VSUBS VSUBS VSUBS VSUBS VSUBS VSUBS VSUBS VSUBS VSUBS
+ sky130_fd_sc_hd__xnor2_1_12/a_377_297# sky130_fd_sc_hd__xnor2_1
Xsky130_fd_sc_hd__decap_12_663 VSUBS VSUBS VSUBS VSUBS sky130_fd_sc_hd__decap_12
Xsky130_fd_sc_hd__decap_12_641 VSUBS VSUBS VSUBS VSUBS sky130_fd_sc_hd__decap_12
Xsky130_fd_sc_hd__decap_12_652 VSUBS VSUBS VSUBS VSUBS sky130_fd_sc_hd__decap_12
Xsky130_fd_sc_hd__decap_12_674 VSUBS VSUBS VSUBS VSUBS sky130_fd_sc_hd__decap_12
Xsky130_fd_sc_hd__decap_12_685 VSUBS VSUBS VSUBS VSUBS sky130_fd_sc_hd__decap_12
Xsky130_fd_sc_hd__decap_12_696 VSUBS VSUBS VSUBS VSUBS sky130_fd_sc_hd__decap_12
Xsky130_fd_sc_hd__decap_12_630 VSUBS VSUBS VSUBS VSUBS sky130_fd_sc_hd__decap_12
Xsky130_fd_sc_hd__clkbuf_16_4 VSUBS VSUBS VSUBS VSUBS VSUBS VSUBS VSUBS sky130_fd_sc_hd__clkbuf_16
Xsky130_fd_sc_hd__nor4_1_4 VSUBS VSUBS VSUBS VSUBS VSUBS VSUBS VSUBS VSUBS VSUBS sky130_fd_sc_hd__nor4_1
Xsky130_fd_sc_hd__decap_12_8 VSUBS VSUBS VSUBS VSUBS sky130_fd_sc_hd__decap_12
Xsky130_fd_sc_hd__a22oi_1_3 VSUBS VSUBS VSUBS VSUBS VSUBS VSUBS VSUBS VSUBS VSUBS
+ sky130_fd_sc_hd__a22oi_1_3/a_381_47# VSUBS sky130_fd_sc_hd__a22oi_1
Xsky130_fd_sc_hd__decap_12_471 VSUBS VSUBS VSUBS VSUBS sky130_fd_sc_hd__decap_12
Xsky130_fd_sc_hd__decap_12_482 VSUBS VSUBS VSUBS VSUBS sky130_fd_sc_hd__decap_12
Xsky130_fd_sc_hd__decap_12_460 VSUBS VSUBS VSUBS VSUBS sky130_fd_sc_hd__decap_12
Xsky130_fd_sc_hd__decap_12_493 VSUBS VSUBS VSUBS VSUBS sky130_fd_sc_hd__decap_12
Xsky130_fd_sc_hd__decap_8_5 VSUBS VSUBS VSUBS VSUBS sky130_fd_sc_hd__decap_8
Xsky130_fd_sc_hd__decap_3_174 VSUBS VSUBS VSUBS VSUBS sky130_fd_sc_hd__decap_3
Xsky130_fd_sc_hd__decap_3_185 VSUBS VSUBS VSUBS VSUBS sky130_fd_sc_hd__decap_3
Xsky130_fd_sc_hd__decap_3_130 VSUBS VSUBS VSUBS VSUBS sky130_fd_sc_hd__decap_3
Xsky130_fd_sc_hd__decap_3_141 VSUBS VSUBS VSUBS VSUBS sky130_fd_sc_hd__decap_3
Xsky130_fd_sc_hd__decap_3_196 VSUBS VSUBS VSUBS VSUBS sky130_fd_sc_hd__decap_3
Xsky130_fd_sc_hd__decap_3_163 VSUBS VSUBS VSUBS VSUBS sky130_fd_sc_hd__decap_3
Xsky130_fd_sc_hd__decap_3_152 VSUBS VSUBS VSUBS VSUBS sky130_fd_sc_hd__decap_3
Xsky130_fd_sc_hd__a21oi_1_2 VSUBS VSUBS VSUBS VSUBS VSUBS VSUBS VSUBS VSUBS VSUBS
+ sky130_fd_sc_hd__a21oi_1
Xsky130_fd_sc_hd__decap_12_290 VSUBS VSUBS VSUBS VSUBS sky130_fd_sc_hd__decap_12
Xsky130_fd_sc_hd__decap_6_2 VSUBS VSUBS VSUBS VSUBS sky130_fd_sc_hd__decap_6
Xsky130_fd_sc_hd__decap_8_211 VSUBS VSUBS VSUBS VSUBS sky130_fd_sc_hd__decap_8
Xsky130_fd_sc_hd__decap_8_200 VSUBS VSUBS VSUBS VSUBS sky130_fd_sc_hd__decap_8
Xsky130_fd_sc_hd__decap_8_255 VSUBS VSUBS VSUBS VSUBS sky130_fd_sc_hd__decap_8
Xsky130_fd_sc_hd__decap_8_233 VSUBS VSUBS VSUBS VSUBS sky130_fd_sc_hd__decap_8
Xsky130_fd_sc_hd__decap_8_222 VSUBS VSUBS VSUBS VSUBS sky130_fd_sc_hd__decap_8
Xsky130_fd_sc_hd__decap_8_244 VSUBS VSUBS VSUBS VSUBS sky130_fd_sc_hd__decap_8
Xsky130_fd_sc_hd__decap_8_266 VSUBS VSUBS VSUBS VSUBS sky130_fd_sc_hd__decap_8
Xsky130_fd_sc_hd__decap_8_277 VSUBS VSUBS VSUBS VSUBS sky130_fd_sc_hd__decap_8
Xsky130_fd_sc_hd__decap_12_845 VSUBS VSUBS VSUBS VSUBS sky130_fd_sc_hd__decap_12
Xsky130_fd_sc_hd__decap_12_889 VSUBS VSUBS VSUBS VSUBS sky130_fd_sc_hd__decap_12
Xsky130_fd_sc_hd__decap_12_834 VSUBS VSUBS VSUBS VSUBS sky130_fd_sc_hd__decap_12
Xsky130_fd_sc_hd__decap_12_823 VSUBS VSUBS VSUBS VSUBS sky130_fd_sc_hd__decap_12
Xsky130_fd_sc_hd__decap_12_856 VSUBS VSUBS VSUBS VSUBS sky130_fd_sc_hd__decap_12
Xsky130_fd_sc_hd__decap_12_812 VSUBS VSUBS VSUBS VSUBS sky130_fd_sc_hd__decap_12
Xsky130_fd_sc_hd__decap_12_878 VSUBS VSUBS VSUBS VSUBS sky130_fd_sc_hd__decap_12
Xsky130_fd_sc_hd__decap_12_801 VSUBS VSUBS VSUBS VSUBS sky130_fd_sc_hd__decap_12
Xsky130_fd_sc_hd__decap_12_867 VSUBS VSUBS VSUBS VSUBS sky130_fd_sc_hd__decap_12
Xsky130_fd_sc_hd__decap_3_90 VSUBS VSUBS VSUBS VSUBS sky130_fd_sc_hd__decap_3
Xsky130_fd_sc_hd__decap_8_79 VSUBS VSUBS VSUBS VSUBS sky130_fd_sc_hd__decap_8
Xsky130_fd_sc_hd__decap_8_13 VSUBS VSUBS VSUBS VSUBS sky130_fd_sc_hd__decap_8
Xsky130_fd_sc_hd__decap_8_35 VSUBS VSUBS VSUBS VSUBS sky130_fd_sc_hd__decap_8
Xsky130_fd_sc_hd__decap_8_24 VSUBS VSUBS VSUBS VSUBS sky130_fd_sc_hd__decap_8
Xsky130_fd_sc_hd__decap_8_57 VSUBS VSUBS VSUBS VSUBS sky130_fd_sc_hd__decap_8
Xsky130_fd_sc_hd__decap_8_68 VSUBS VSUBS VSUBS VSUBS sky130_fd_sc_hd__decap_8
Xsky130_fd_sc_hd__decap_8_46 VSUBS VSUBS VSUBS VSUBS sky130_fd_sc_hd__decap_8
Xsky130_fd_sc_hd__decap_12_119 VSUBS VSUBS VSUBS VSUBS sky130_fd_sc_hd__decap_12
Xsky130_fd_sc_hd__decap_12_108 VSUBS VSUBS VSUBS VSUBS sky130_fd_sc_hd__decap_12
Xsky130_fd_sc_hd__decap_12_1129 VSUBS VSUBS VSUBS VSUBS sky130_fd_sc_hd__decap_12
Xsky130_fd_sc_hd__decap_12_1118 VSUBS VSUBS VSUBS VSUBS sky130_fd_sc_hd__decap_12
Xsky130_fd_sc_hd__decap_12_1107 VSUBS VSUBS VSUBS VSUBS sky130_fd_sc_hd__decap_12
Xsky130_fd_sc_hd__nand3_1_8 VSUBS VSUBS VSUBS VSUBS VSUBS VSUBS VSUBS VSUBS sky130_fd_sc_hd__nand3_1
Xsky130_fd_sc_hd__xnor2_1_13 VSUBS VSUBS VSUBS VSUBS VSUBS VSUBS VSUBS VSUBS VSUBS
+ sky130_fd_sc_hd__xnor2_1_13/a_377_297# sky130_fd_sc_hd__xnor2_1
Xsky130_fd_sc_hd__decap_12_697 VSUBS VSUBS VSUBS VSUBS sky130_fd_sc_hd__decap_12
Xsky130_fd_sc_hd__decap_12_664 VSUBS VSUBS VSUBS VSUBS sky130_fd_sc_hd__decap_12
Xsky130_fd_sc_hd__decap_12_675 VSUBS VSUBS VSUBS VSUBS sky130_fd_sc_hd__decap_12
Xsky130_fd_sc_hd__decap_12_642 VSUBS VSUBS VSUBS VSUBS sky130_fd_sc_hd__decap_12
Xsky130_fd_sc_hd__decap_12_686 VSUBS VSUBS VSUBS VSUBS sky130_fd_sc_hd__decap_12
Xsky130_fd_sc_hd__decap_12_653 VSUBS VSUBS VSUBS VSUBS sky130_fd_sc_hd__decap_12
Xsky130_fd_sc_hd__decap_12_620 VSUBS VSUBS VSUBS VSUBS sky130_fd_sc_hd__decap_12
Xsky130_fd_sc_hd__decap_12_631 VSUBS VSUBS VSUBS VSUBS sky130_fd_sc_hd__decap_12
Xsky130_fd_sc_hd__xnor2_1_24 VSUBS VSUBS VSUBS VSUBS VSUBS VSUBS VSUBS VSUBS VSUBS
+ sky130_fd_sc_hd__xnor2_1_24/a_377_297# sky130_fd_sc_hd__xnor2_1
Xsky130_fd_sc_hd__clkbuf_16_5 VSUBS VSUBS VSUBS VSUBS VSUBS VSUBS VSUBS sky130_fd_sc_hd__clkbuf_16
Xsky130_fd_sc_hd__nor4_1_5 VSUBS VSUBS VSUBS VSUBS VSUBS VSUBS VSUBS VSUBS VSUBS sky130_fd_sc_hd__nor4_1
Xsky130_fd_sc_hd__a22oi_1_4 VSUBS VSUBS VSUBS VSUBS VSUBS VSUBS VSUBS VSUBS VSUBS
+ sky130_fd_sc_hd__a22oi_1_4/a_381_47# VSUBS sky130_fd_sc_hd__a22oi_1
Xsky130_fd_sc_hd__decap_12_9 VSUBS VSUBS VSUBS VSUBS sky130_fd_sc_hd__decap_12
Xsky130_fd_sc_hd__decap_12_450 VSUBS VSUBS VSUBS VSUBS sky130_fd_sc_hd__decap_12
Xsky130_fd_sc_hd__decap_12_461 VSUBS VSUBS VSUBS VSUBS sky130_fd_sc_hd__decap_12
Xsky130_fd_sc_hd__decap_12_483 VSUBS VSUBS VSUBS VSUBS sky130_fd_sc_hd__decap_12
Xsky130_fd_sc_hd__decap_12_472 VSUBS VSUBS VSUBS VSUBS sky130_fd_sc_hd__decap_12
Xsky130_fd_sc_hd__decap_12_494 VSUBS VSUBS VSUBS VSUBS sky130_fd_sc_hd__decap_12
Xsky130_fd_sc_hd__decap_8_6 VSUBS VSUBS VSUBS VSUBS sky130_fd_sc_hd__decap_8
Xsky130_fd_sc_hd__decap_3_175 VSUBS VSUBS VSUBS VSUBS sky130_fd_sc_hd__decap_3
Xsky130_fd_sc_hd__decap_3_142 VSUBS VSUBS VSUBS VSUBS sky130_fd_sc_hd__decap_3
Xsky130_fd_sc_hd__decap_3_186 VSUBS VSUBS VSUBS VSUBS sky130_fd_sc_hd__decap_3
Xsky130_fd_sc_hd__decap_3_131 VSUBS VSUBS VSUBS VSUBS sky130_fd_sc_hd__decap_3
Xsky130_fd_sc_hd__decap_3_164 VSUBS VSUBS VSUBS VSUBS sky130_fd_sc_hd__decap_3
Xsky130_fd_sc_hd__decap_3_120 VSUBS VSUBS VSUBS VSUBS sky130_fd_sc_hd__decap_3
Xsky130_fd_sc_hd__decap_3_153 VSUBS VSUBS VSUBS VSUBS sky130_fd_sc_hd__decap_3
Xsky130_fd_sc_hd__decap_3_197 VSUBS VSUBS VSUBS VSUBS sky130_fd_sc_hd__decap_3
Xsky130_fd_sc_hd__a21oi_1_3 VSUBS VSUBS VSUBS VSUBS VSUBS VSUBS VSUBS VSUBS VSUBS
+ sky130_fd_sc_hd__a21oi_1
Xsky130_fd_sc_hd__decap_12_291 VSUBS VSUBS VSUBS VSUBS sky130_fd_sc_hd__decap_12
Xsky130_fd_sc_hd__decap_12_280 VSUBS VSUBS VSUBS VSUBS sky130_fd_sc_hd__decap_12
Xsky130_fd_sc_hd__decap_6_3 VSUBS VSUBS VSUBS VSUBS sky130_fd_sc_hd__decap_6
Xsky130_fd_sc_hd__decap_8_223 VSUBS VSUBS VSUBS VSUBS sky130_fd_sc_hd__decap_8
Xsky130_fd_sc_hd__decap_8_234 VSUBS VSUBS VSUBS VSUBS sky130_fd_sc_hd__decap_8
Xsky130_fd_sc_hd__decap_8_212 VSUBS VSUBS VSUBS VSUBS sky130_fd_sc_hd__decap_8
Xsky130_fd_sc_hd__decap_8_201 VSUBS VSUBS VSUBS VSUBS sky130_fd_sc_hd__decap_8
Xsky130_fd_sc_hd__decap_8_256 VSUBS VSUBS VSUBS VSUBS sky130_fd_sc_hd__decap_8
Xsky130_fd_sc_hd__decap_8_245 VSUBS VSUBS VSUBS VSUBS sky130_fd_sc_hd__decap_8
Xsky130_fd_sc_hd__decap_8_267 VSUBS VSUBS VSUBS VSUBS sky130_fd_sc_hd__decap_8
Xsky130_fd_sc_hd__nand2b_1_0 VSUBS VSUBS VSUBS VSUBS VSUBS VSUBS VSUBS VSUBS sky130_fd_sc_hd__nand2b_1
Xsky130_fd_sc_hd__decap_8_278 VSUBS VSUBS VSUBS VSUBS sky130_fd_sc_hd__decap_8
Xsky130_fd_sc_hd__decap_6_90 VSUBS VSUBS VSUBS VSUBS sky130_fd_sc_hd__decap_6
Xsky130_fd_sc_hd__decap_4_0 VSUBS VSUBS VSUBS VSUBS sky130_fd_sc_hd__decap_4
Xsky130_fd_sc_hd__conb_1_0 VSUBS VSUBS VSUBS VSUBS VSUBS VSUBS sky130_fd_sc_hd__conb_1_0/a_21_232#
+ sky130_fd_sc_hd__conb_1_0/a_159_232# sky130_fd_sc_hd__conb_1
Xsky130_fd_sc_hd__o41ai_1_0 VSUBS VSUBS VSUBS VSUBS VSUBS VSUBS VSUBS VSUBS VSUBS
+ VSUBS VSUBS sky130_fd_sc_hd__o41ai_1
Xsky130_fd_sc_hd__o211ai_1_0 VSUBS VSUBS VSUBS VSUBS VSUBS VSUBS sky130_fd_sc_hd__o211ai_1_0/C1
+ VSUBS VSUBS VSUBS sky130_fd_sc_hd__o211ai_1
Xsky130_fd_sc_hd__decap_12_802 VSUBS VSUBS VSUBS VSUBS sky130_fd_sc_hd__decap_12
Xsky130_fd_sc_hd__decap_12_846 VSUBS VSUBS VSUBS VSUBS sky130_fd_sc_hd__decap_12
Xsky130_fd_sc_hd__decap_12_835 VSUBS VSUBS VSUBS VSUBS sky130_fd_sc_hd__decap_12
Xsky130_fd_sc_hd__decap_12_868 VSUBS VSUBS VSUBS VSUBS sky130_fd_sc_hd__decap_12
Xsky130_fd_sc_hd__decap_12_813 VSUBS VSUBS VSUBS VSUBS sky130_fd_sc_hd__decap_12
Xsky130_fd_sc_hd__decap_12_857 VSUBS VSUBS VSUBS VSUBS sky130_fd_sc_hd__decap_12
Xsky130_fd_sc_hd__decap_12_824 VSUBS VSUBS VSUBS VSUBS sky130_fd_sc_hd__decap_12
Xsky130_fd_sc_hd__decap_12_879 VSUBS VSUBS VSUBS VSUBS sky130_fd_sc_hd__decap_12
Xsky130_fd_sc_hd__decap_3_80 VSUBS VSUBS VSUBS VSUBS sky130_fd_sc_hd__decap_3
Xsky130_fd_sc_hd__decap_3_91 VSUBS VSUBS VSUBS VSUBS sky130_fd_sc_hd__decap_3
Xsky130_fd_sc_hd__decap_8_25 VSUBS VSUBS VSUBS VSUBS sky130_fd_sc_hd__decap_8
Xsky130_fd_sc_hd__decap_8_36 VSUBS VSUBS VSUBS VSUBS sky130_fd_sc_hd__decap_8
Xsky130_fd_sc_hd__decap_8_69 VSUBS VSUBS VSUBS VSUBS sky130_fd_sc_hd__decap_8
Xsky130_fd_sc_hd__decap_8_14 VSUBS VSUBS VSUBS VSUBS sky130_fd_sc_hd__decap_8
Xsky130_fd_sc_hd__decap_8_58 VSUBS VSUBS VSUBS VSUBS sky130_fd_sc_hd__decap_8
Xsky130_fd_sc_hd__decap_8_47 VSUBS VSUBS VSUBS VSUBS sky130_fd_sc_hd__decap_8
Xsky130_fd_sc_hd__decap_12_109 VSUBS VSUBS VSUBS VSUBS sky130_fd_sc_hd__decap_12
Xsky130_fd_sc_hd__decap_12_1108 VSUBS VSUBS VSUBS VSUBS sky130_fd_sc_hd__decap_12
Xsky130_fd_sc_hd__decap_12_1119 VSUBS VSUBS VSUBS VSUBS sky130_fd_sc_hd__decap_12
Xsky130_fd_sc_hd__decap_12_643 VSUBS VSUBS VSUBS VSUBS sky130_fd_sc_hd__decap_12
Xsky130_fd_sc_hd__decap_12_621 VSUBS VSUBS VSUBS VSUBS sky130_fd_sc_hd__decap_12
Xsky130_fd_sc_hd__decap_12_610 VSUBS VSUBS VSUBS VSUBS sky130_fd_sc_hd__decap_12
Xsky130_fd_sc_hd__decap_12_632 VSUBS VSUBS VSUBS VSUBS sky130_fd_sc_hd__decap_12
Xsky130_fd_sc_hd__decap_12_698 VSUBS VSUBS VSUBS VSUBS sky130_fd_sc_hd__decap_12
Xsky130_fd_sc_hd__xnor2_1_25 VSUBS VSUBS VSUBS VSUBS VSUBS VSUBS VSUBS VSUBS VSUBS
+ sky130_fd_sc_hd__xnor2_1_25/a_377_297# sky130_fd_sc_hd__xnor2_1
Xsky130_fd_sc_hd__xnor2_1_14 VSUBS VSUBS VSUBS VSUBS VSUBS VSUBS VSUBS VSUBS VSUBS
+ VSUBS sky130_fd_sc_hd__xnor2_1
Xsky130_fd_sc_hd__decap_12_665 VSUBS VSUBS VSUBS VSUBS sky130_fd_sc_hd__decap_12
Xsky130_fd_sc_hd__decap_12_654 VSUBS VSUBS VSUBS VSUBS sky130_fd_sc_hd__decap_12
Xsky130_fd_sc_hd__decap_12_676 VSUBS VSUBS VSUBS VSUBS sky130_fd_sc_hd__decap_12
Xsky130_fd_sc_hd__decap_12_687 VSUBS VSUBS VSUBS VSUBS sky130_fd_sc_hd__decap_12
Xsky130_fd_sc_hd__or4_1_0 VSUBS VSUBS VSUBS VSUBS VSUBS VSUBS VSUBS VSUBS VSUBS VSUBS
+ VSUBS sky130_fd_sc_hd__or4_1
Xsky130_fd_sc_hd__clkbuf_16_6 VSUBS VSUBS VSUBS VSUBS VSUBS VSUBS VSUBS sky130_fd_sc_hd__clkbuf_16
Xsky130_fd_sc_hd__a22oi_1_5 VSUBS VSUBS VSUBS VSUBS VSUBS VSUBS VSUBS sky130_fd_sc_hd__a22oi_1_5/A1
+ VSUBS VSUBS VSUBS sky130_fd_sc_hd__a22oi_1
Xsky130_fd_sc_hd__a222oi_1_0 VSUBS VSUBS VSUBS VSUBS VSUBS VSUBS VSUBS VSUBS VSUBS
+ VSUBS VSUBS VSUBS VSUBS sky130_fd_sc_hd__a222oi_1
Xsky130_fd_sc_hd__decap_12_484 VSUBS VSUBS VSUBS VSUBS sky130_fd_sc_hd__decap_12
Xsky130_fd_sc_hd__decap_12_473 VSUBS VSUBS VSUBS VSUBS sky130_fd_sc_hd__decap_12
Xsky130_fd_sc_hd__decap_12_462 VSUBS VSUBS VSUBS VSUBS sky130_fd_sc_hd__decap_12
Xsky130_fd_sc_hd__decap_12_451 VSUBS VSUBS VSUBS VSUBS sky130_fd_sc_hd__decap_12
Xsky130_fd_sc_hd__decap_12_440 VSUBS VSUBS VSUBS VSUBS sky130_fd_sc_hd__decap_12
Xsky130_fd_sc_hd__decap_12_495 VSUBS VSUBS VSUBS VSUBS sky130_fd_sc_hd__decap_12
Xsky130_fd_sc_hd__decap_8_7 VSUBS VSUBS VSUBS VSUBS sky130_fd_sc_hd__decap_8
Xsky130_fd_sc_hd__decap_3_143 VSUBS VSUBS VSUBS VSUBS sky130_fd_sc_hd__decap_3
Xsky130_fd_sc_hd__decap_3_132 VSUBS VSUBS VSUBS VSUBS sky130_fd_sc_hd__decap_3
Xsky130_fd_sc_hd__decap_3_121 VSUBS VSUBS VSUBS VSUBS sky130_fd_sc_hd__decap_3
Xsky130_fd_sc_hd__decap_3_110 VSUBS VSUBS VSUBS VSUBS sky130_fd_sc_hd__decap_3
Xsky130_fd_sc_hd__decap_3_176 VSUBS VSUBS VSUBS VSUBS sky130_fd_sc_hd__decap_3
Xsky130_fd_sc_hd__decap_3_187 VSUBS VSUBS VSUBS VSUBS sky130_fd_sc_hd__decap_3
Xsky130_fd_sc_hd__decap_3_165 VSUBS VSUBS VSUBS VSUBS sky130_fd_sc_hd__decap_3
Xsky130_fd_sc_hd__decap_3_154 VSUBS VSUBS VSUBS VSUBS sky130_fd_sc_hd__decap_3
Xsky130_fd_sc_hd__decap_3_198 VSUBS VSUBS VSUBS VSUBS sky130_fd_sc_hd__decap_3
Xsky130_fd_sc_hd__a21oi_1_4 VSUBS VSUBS VSUBS VSUBS VSUBS VSUBS VSUBS VSUBS VSUBS
+ sky130_fd_sc_hd__a21oi_1
Xsky130_fd_sc_hd__decap_12_270 VSUBS VSUBS VSUBS VSUBS sky130_fd_sc_hd__decap_12
Xsky130_fd_sc_hd__decap_12_292 VSUBS VSUBS VSUBS VSUBS sky130_fd_sc_hd__decap_12
Xsky130_fd_sc_hd__decap_12_281 VSUBS VSUBS VSUBS VSUBS sky130_fd_sc_hd__decap_12
Xsky130_fd_sc_hd__decap_6_4 VSUBS VSUBS VSUBS VSUBS sky130_fd_sc_hd__decap_6
Xsky130_fd_sc_hd__decap_8_257 VSUBS VSUBS VSUBS VSUBS sky130_fd_sc_hd__decap_8
Xsky130_fd_sc_hd__decap_8_246 VSUBS VSUBS VSUBS VSUBS sky130_fd_sc_hd__decap_8
Xsky130_fd_sc_hd__decap_8_235 VSUBS VSUBS VSUBS VSUBS sky130_fd_sc_hd__decap_8
Xsky130_fd_sc_hd__decap_8_224 VSUBS VSUBS VSUBS VSUBS sky130_fd_sc_hd__decap_8
Xsky130_fd_sc_hd__decap_8_213 VSUBS VSUBS VSUBS VSUBS sky130_fd_sc_hd__decap_8
Xsky130_fd_sc_hd__decap_8_202 VSUBS VSUBS VSUBS VSUBS sky130_fd_sc_hd__decap_8
Xsky130_fd_sc_hd__decap_8_268 VSUBS VSUBS VSUBS VSUBS sky130_fd_sc_hd__decap_8
Xsky130_fd_sc_hd__decap_8_279 VSUBS VSUBS VSUBS VSUBS sky130_fd_sc_hd__decap_8
Xsky130_fd_sc_hd__nand2b_1_1 VSUBS VSUBS VSUBS VSUBS VSUBS VSUBS VSUBS VSUBS sky130_fd_sc_hd__nand2b_1
Xsky130_fd_sc_hd__decap_6_80 VSUBS VSUBS VSUBS VSUBS sky130_fd_sc_hd__decap_6
Xsky130_fd_sc_hd__decap_6_91 VSUBS VSUBS VSUBS VSUBS sky130_fd_sc_hd__decap_6
Xsky130_fd_sc_hd__nor4bb_1_0 VSUBS VSUBS VSUBS VSUBS VSUBS VSUBS VSUBS VSUBS VSUBS
+ VSUBS VSUBS sky130_fd_sc_hd__nor4bb_1
Xsky130_fd_sc_hd__decap_4_1 VSUBS VSUBS VSUBS VSUBS sky130_fd_sc_hd__decap_4
Xsky130_fd_sc_hd__conb_1_1 VSUBS VSUBS VSUBS VSUBS VSUBS VSUBS sky130_fd_sc_hd__conb_1_1/a_21_232#
+ sky130_fd_sc_hd__conb_1_1/a_159_232# sky130_fd_sc_hd__conb_1
Xsky130_fd_sc_hd__o211ai_1_1 VSUBS VSUBS VSUBS VSUBS VSUBS VSUBS VSUBS VSUBS VSUBS
+ VSUBS sky130_fd_sc_hd__o211ai_1
Xsky130_fd_sc_hd__decap_12_836 VSUBS VSUBS VSUBS VSUBS sky130_fd_sc_hd__decap_12
Xsky130_fd_sc_hd__decap_12_825 VSUBS VSUBS VSUBS VSUBS sky130_fd_sc_hd__decap_12
Xsky130_fd_sc_hd__decap_12_803 VSUBS VSUBS VSUBS VSUBS sky130_fd_sc_hd__decap_12
Xsky130_fd_sc_hd__decap_12_814 VSUBS VSUBS VSUBS VSUBS sky130_fd_sc_hd__decap_12
Xsky130_fd_sc_hd__decap_3_70 VSUBS VSUBS VSUBS VSUBS sky130_fd_sc_hd__decap_3
Xsky130_fd_sc_hd__decap_3_81 VSUBS VSUBS VSUBS VSUBS sky130_fd_sc_hd__decap_3
Xsky130_fd_sc_hd__decap_12_847 VSUBS VSUBS VSUBS VSUBS sky130_fd_sc_hd__decap_12
Xsky130_fd_sc_hd__decap_12_858 VSUBS VSUBS VSUBS VSUBS sky130_fd_sc_hd__decap_12
Xsky130_fd_sc_hd__decap_12_869 VSUBS VSUBS VSUBS VSUBS sky130_fd_sc_hd__decap_12
Xsky130_fd_sc_hd__decap_3_92 VSUBS VSUBS VSUBS VSUBS sky130_fd_sc_hd__decap_3
Xsky130_fd_sc_hd__decap_8_26 VSUBS VSUBS VSUBS VSUBS sky130_fd_sc_hd__decap_8
Xsky130_fd_sc_hd__decap_8_37 VSUBS VSUBS VSUBS VSUBS sky130_fd_sc_hd__decap_8
Xsky130_fd_sc_hd__decap_8_15 VSUBS VSUBS VSUBS VSUBS sky130_fd_sc_hd__decap_8
Xsky130_fd_sc_hd__decap_8_48 VSUBS VSUBS VSUBS VSUBS sky130_fd_sc_hd__decap_8
Xsky130_fd_sc_hd__decap_8_59 VSUBS VSUBS VSUBS VSUBS sky130_fd_sc_hd__decap_8
Xsky130_fd_sc_hd__decap_12_1109 VSUBS VSUBS VSUBS VSUBS sky130_fd_sc_hd__decap_12
Xsky130_fd_sc_hd__xnor2_1_15 VSUBS VSUBS VSUBS VSUBS VSUBS VSUBS VSUBS VSUBS VSUBS
+ sky130_fd_sc_hd__xnor2_1_15/a_377_297# sky130_fd_sc_hd__xnor2_1
Xsky130_fd_sc_hd__decap_12_666 VSUBS VSUBS VSUBS VSUBS sky130_fd_sc_hd__decap_12
Xsky130_fd_sc_hd__decap_12_644 VSUBS VSUBS VSUBS VSUBS sky130_fd_sc_hd__decap_12
Xsky130_fd_sc_hd__decap_12_655 VSUBS VSUBS VSUBS VSUBS sky130_fd_sc_hd__decap_12
Xsky130_fd_sc_hd__decap_12_677 VSUBS VSUBS VSUBS VSUBS sky130_fd_sc_hd__decap_12
Xsky130_fd_sc_hd__decap_12_600 VSUBS VSUBS VSUBS VSUBS sky130_fd_sc_hd__decap_12
Xsky130_fd_sc_hd__decap_12_611 VSUBS VSUBS VSUBS VSUBS sky130_fd_sc_hd__decap_12
Xsky130_fd_sc_hd__decap_12_622 VSUBS VSUBS VSUBS VSUBS sky130_fd_sc_hd__decap_12
Xsky130_fd_sc_hd__decap_12_633 VSUBS VSUBS VSUBS VSUBS sky130_fd_sc_hd__decap_12
Xsky130_fd_sc_hd__decap_12_699 VSUBS VSUBS VSUBS VSUBS sky130_fd_sc_hd__decap_12
Xsky130_fd_sc_hd__decap_12_688 VSUBS VSUBS VSUBS VSUBS sky130_fd_sc_hd__decap_12
Xsky130_fd_sc_hd__o21ai_0_60 VSUBS VSUBS VSUBS VSUBS VSUBS VSUBS VSUBS VSUBS VSUBS
+ sky130_fd_sc_hd__o21ai_0
Xsky130_fd_sc_hd__clkbuf_16_7 VSUBS VSUBS VSUBS VSUBS VSUBS VSUBS VSUBS sky130_fd_sc_hd__clkbuf_16
Xsky130_fd_sc_hd__a22oi_1_6 VSUBS VSUBS VSUBS VSUBS VSUBS VSUBS VSUBS VSUBS VSUBS
+ sky130_fd_sc_hd__a22oi_1_6/a_381_47# VSUBS sky130_fd_sc_hd__a22oi_1
Xsky130_fd_sc_hd__and2_0_0 VSUBS VSUBS VSUBS VSUBS VSUBS VSUBS VSUBS VSUBS sky130_fd_sc_hd__and2_0
Xsky130_fd_sc_hd__decap_12_485 VSUBS VSUBS VSUBS VSUBS sky130_fd_sc_hd__decap_12
Xsky130_fd_sc_hd__decap_12_474 VSUBS VSUBS VSUBS VSUBS sky130_fd_sc_hd__decap_12
Xsky130_fd_sc_hd__decap_12_463 VSUBS VSUBS VSUBS VSUBS sky130_fd_sc_hd__decap_12
Xsky130_fd_sc_hd__decap_12_452 VSUBS VSUBS VSUBS VSUBS sky130_fd_sc_hd__decap_12
Xsky130_fd_sc_hd__decap_12_430 VSUBS VSUBS VSUBS VSUBS sky130_fd_sc_hd__decap_12
Xsky130_fd_sc_hd__decap_12_496 VSUBS VSUBS VSUBS VSUBS sky130_fd_sc_hd__decap_12
Xsky130_fd_sc_hd__decap_12_441 VSUBS VSUBS VSUBS VSUBS sky130_fd_sc_hd__decap_12
Xsky130_fd_sc_hd__decap_8_8 VSUBS VSUBS VSUBS VSUBS sky130_fd_sc_hd__decap_8
Xsky130_fd_sc_hd__decap_3_177 VSUBS VSUBS VSUBS VSUBS sky130_fd_sc_hd__decap_3
Xsky130_fd_sc_hd__decap_3_144 VSUBS VSUBS VSUBS VSUBS sky130_fd_sc_hd__decap_3
Xsky130_fd_sc_hd__decap_3_133 VSUBS VSUBS VSUBS VSUBS sky130_fd_sc_hd__decap_3
Xsky130_fd_sc_hd__decap_3_155 VSUBS VSUBS VSUBS VSUBS sky130_fd_sc_hd__decap_3
Xsky130_fd_sc_hd__decap_3_166 VSUBS VSUBS VSUBS VSUBS sky130_fd_sc_hd__decap_3
Xsky130_fd_sc_hd__decap_3_122 VSUBS VSUBS VSUBS VSUBS sky130_fd_sc_hd__decap_3
Xsky130_fd_sc_hd__decap_3_111 VSUBS VSUBS VSUBS VSUBS sky130_fd_sc_hd__decap_3
Xsky130_fd_sc_hd__decap_3_100 VSUBS VSUBS VSUBS VSUBS sky130_fd_sc_hd__decap_3
Xsky130_fd_sc_hd__decap_3_188 VSUBS VSUBS VSUBS VSUBS sky130_fd_sc_hd__decap_3
Xsky130_fd_sc_hd__decap_3_199 VSUBS VSUBS VSUBS VSUBS sky130_fd_sc_hd__decap_3
Xsky130_fd_sc_hd__a21oi_1_5 VSUBS VSUBS VSUBS VSUBS sky130_fd_sc_hd__a21oi_1_5/A2
+ sky130_fd_sc_hd__a21oi_1_5/A1 VSUBS VSUBS VSUBS sky130_fd_sc_hd__a21oi_1
Xsky130_fd_sc_hd__decap_12_271 VSUBS VSUBS VSUBS VSUBS sky130_fd_sc_hd__decap_12
Xsky130_fd_sc_hd__decap_12_282 VSUBS VSUBS VSUBS VSUBS sky130_fd_sc_hd__decap_12
Xsky130_fd_sc_hd__decap_12_293 VSUBS VSUBS VSUBS VSUBS sky130_fd_sc_hd__decap_12
Xsky130_fd_sc_hd__decap_12_260 VSUBS VSUBS VSUBS VSUBS sky130_fd_sc_hd__decap_12
Xsky130_fd_sc_hd__decap_6_5 VSUBS VSUBS VSUBS VSUBS sky130_fd_sc_hd__decap_6
Xsky130_fd_sc_hd__decap_8_225 VSUBS VSUBS VSUBS VSUBS sky130_fd_sc_hd__decap_8
Xsky130_fd_sc_hd__decap_8_247 VSUBS VSUBS VSUBS VSUBS sky130_fd_sc_hd__decap_8
Xsky130_fd_sc_hd__decap_8_236 VSUBS VSUBS VSUBS VSUBS sky130_fd_sc_hd__decap_8
Xsky130_fd_sc_hd__decap_8_258 VSUBS VSUBS VSUBS VSUBS sky130_fd_sc_hd__decap_8
Xsky130_fd_sc_hd__decap_8_214 VSUBS VSUBS VSUBS VSUBS sky130_fd_sc_hd__decap_8
Xsky130_fd_sc_hd__decap_8_203 VSUBS VSUBS VSUBS VSUBS sky130_fd_sc_hd__decap_8
Xsky130_fd_sc_hd__decap_8_269 VSUBS VSUBS VSUBS VSUBS sky130_fd_sc_hd__decap_8
Xsky130_fd_sc_hd__nand2b_1_2 VSUBS VSUBS VSUBS VSUBS VSUBS VSUBS VSUBS VSUBS sky130_fd_sc_hd__nand2b_1
Xsky130_fd_sc_hd__decap_6_81 VSUBS VSUBS VSUBS VSUBS sky130_fd_sc_hd__decap_6
Xsky130_fd_sc_hd__decap_6_70 VSUBS VSUBS VSUBS VSUBS sky130_fd_sc_hd__decap_6
Xsky130_fd_sc_hd__decap_6_92 VSUBS VSUBS VSUBS VSUBS sky130_fd_sc_hd__decap_6
Xsky130_fd_sc_hd__a32oi_1_0 VSUBS VSUBS VSUBS VSUBS VSUBS VSUBS VSUBS VSUBS VSUBS
+ VSUBS VSUBS sky130_fd_sc_hd__a32oi_1
Xsky130_fd_sc_hd__nor4bb_1_1 VSUBS VSUBS VSUBS VSUBS VSUBS VSUBS VSUBS VSUBS VSUBS
+ VSUBS VSUBS sky130_fd_sc_hd__nor4bb_1
Xsky130_fd_sc_hd__decap_4_2 VSUBS VSUBS VSUBS VSUBS sky130_fd_sc_hd__decap_4
Xsky130_fd_sc_hd__conb_1_2 VSUBS VSUBS VSUBS VSUBS VSUBS VSUBS sky130_fd_sc_hd__conb_1_2/a_21_232#
+ sky130_fd_sc_hd__conb_1_2/a_159_232# sky130_fd_sc_hd__conb_1
Xsky130_fd_sc_hd__o211ai_1_2 VSUBS VSUBS VSUBS VSUBS VSUBS VSUBS VSUBS VSUBS VSUBS
+ VSUBS sky130_fd_sc_hd__o211ai_1
Xsky130_fd_sc_hd__decap_12_848 VSUBS VSUBS VSUBS VSUBS sky130_fd_sc_hd__decap_12
Xsky130_fd_sc_hd__decap_12_826 VSUBS VSUBS VSUBS VSUBS sky130_fd_sc_hd__decap_12
Xsky130_fd_sc_hd__decap_12_837 VSUBS VSUBS VSUBS VSUBS sky130_fd_sc_hd__decap_12
Xsky130_fd_sc_hd__decap_12_804 VSUBS VSUBS VSUBS VSUBS sky130_fd_sc_hd__decap_12
Xsky130_fd_sc_hd__decap_12_815 VSUBS VSUBS VSUBS VSUBS sky130_fd_sc_hd__decap_12
Xsky130_fd_sc_hd__decap_12_859 VSUBS VSUBS VSUBS VSUBS sky130_fd_sc_hd__decap_12
Xsky130_fd_sc_hd__decap_3_60 VSUBS VSUBS VSUBS VSUBS sky130_fd_sc_hd__decap_3
Xsky130_fd_sc_hd__decap_3_71 VSUBS VSUBS VSUBS VSUBS sky130_fd_sc_hd__decap_3
Xsky130_fd_sc_hd__decap_3_82 VSUBS VSUBS VSUBS VSUBS sky130_fd_sc_hd__decap_3
Xsky130_fd_sc_hd__decap_3_93 VSUBS VSUBS VSUBS VSUBS sky130_fd_sc_hd__decap_3
Xsky130_fd_sc_hd__decap_8_27 VSUBS VSUBS VSUBS VSUBS sky130_fd_sc_hd__decap_8
Xsky130_fd_sc_hd__decap_8_38 VSUBS VSUBS VSUBS VSUBS sky130_fd_sc_hd__decap_8
Xsky130_fd_sc_hd__decap_8_16 VSUBS VSUBS VSUBS VSUBS sky130_fd_sc_hd__decap_8
Xsky130_fd_sc_hd__decap_8_49 VSUBS VSUBS VSUBS VSUBS sky130_fd_sc_hd__decap_8
Xsky130_fd_sc_hd__xnor2_1_16 VSUBS VSUBS VSUBS VSUBS VSUBS VSUBS VSUBS VSUBS VSUBS
+ sky130_fd_sc_hd__xnor2_1_16/a_377_297# sky130_fd_sc_hd__xnor2_1
Xsky130_fd_sc_hd__decap_12_667 VSUBS VSUBS VSUBS VSUBS sky130_fd_sc_hd__decap_12
Xsky130_fd_sc_hd__decap_12_645 VSUBS VSUBS VSUBS VSUBS sky130_fd_sc_hd__decap_12
Xsky130_fd_sc_hd__decap_12_656 VSUBS VSUBS VSUBS VSUBS sky130_fd_sc_hd__decap_12
Xsky130_fd_sc_hd__decap_12_601 VSUBS VSUBS VSUBS VSUBS sky130_fd_sc_hd__decap_12
Xsky130_fd_sc_hd__decap_12_689 VSUBS VSUBS VSUBS VSUBS sky130_fd_sc_hd__decap_12
Xsky130_fd_sc_hd__decap_12_623 VSUBS VSUBS VSUBS VSUBS sky130_fd_sc_hd__decap_12
Xsky130_fd_sc_hd__decap_12_678 VSUBS VSUBS VSUBS VSUBS sky130_fd_sc_hd__decap_12
Xsky130_fd_sc_hd__decap_12_612 VSUBS VSUBS VSUBS VSUBS sky130_fd_sc_hd__decap_12
Xsky130_fd_sc_hd__decap_12_634 VSUBS VSUBS VSUBS VSUBS sky130_fd_sc_hd__decap_12
Xsky130_fd_sc_hd__o21ai_0_50 VSUBS VSUBS VSUBS VSUBS VSUBS VSUBS VSUBS VSUBS VSUBS
+ sky130_fd_sc_hd__o21ai_0
Xsky130_fd_sc_hd__o21ai_0_61 VSUBS VSUBS VSUBS VSUBS VSUBS VSUBS VSUBS VSUBS VSUBS
+ sky130_fd_sc_hd__o21ai_0
Xsky130_fd_sc_hd__nand2_1_0 VSUBS VSUBS VSUBS VSUBS VSUBS VSUBS VSUBS sky130_fd_sc_hd__nand2_1
Xsky130_fd_sc_hd__and2_0_1 VSUBS VSUBS VSUBS VSUBS VSUBS VSUBS VSUBS VSUBS sky130_fd_sc_hd__and2_0
Xsky130_fd_sc_hd__clkbuf_16_8 VSUBS VSUBS VSUBS VSUBS VSUBS VSUBS VSUBS sky130_fd_sc_hd__clkbuf_16
Xsky130_fd_sc_hd__a22oi_1_7 VSUBS VSUBS VSUBS VSUBS VSUBS VSUBS VSUBS VSUBS VSUBS
+ sky130_fd_sc_hd__a22oi_1_7/a_381_47# VSUBS sky130_fd_sc_hd__a22oi_1
Xsky130_fd_sc_hd__decap_6_120 VSUBS VSUBS VSUBS VSUBS sky130_fd_sc_hd__decap_6
Xsky130_fd_sc_hd__decap_12_486 VSUBS VSUBS VSUBS VSUBS sky130_fd_sc_hd__decap_12
Xsky130_fd_sc_hd__decap_12_475 VSUBS VSUBS VSUBS VSUBS sky130_fd_sc_hd__decap_12
Xsky130_fd_sc_hd__decap_12_453 VSUBS VSUBS VSUBS VSUBS sky130_fd_sc_hd__decap_12
Xsky130_fd_sc_hd__decap_12_431 VSUBS VSUBS VSUBS VSUBS sky130_fd_sc_hd__decap_12
Xsky130_fd_sc_hd__decap_12_464 VSUBS VSUBS VSUBS VSUBS sky130_fd_sc_hd__decap_12
Xsky130_fd_sc_hd__decap_12_497 VSUBS VSUBS VSUBS VSUBS sky130_fd_sc_hd__decap_12
Xsky130_fd_sc_hd__decap_12_420 VSUBS VSUBS VSUBS VSUBS sky130_fd_sc_hd__decap_12
Xsky130_fd_sc_hd__decap_12_442 VSUBS VSUBS VSUBS VSUBS sky130_fd_sc_hd__decap_12
Xsky130_fd_sc_hd__decap_8_9 VSUBS VSUBS VSUBS VSUBS sky130_fd_sc_hd__decap_8
Xsky130_fd_sc_hd__decap_3_178 VSUBS VSUBS VSUBS VSUBS sky130_fd_sc_hd__decap_3
Xsky130_fd_sc_hd__decap_3_189 VSUBS VSUBS VSUBS VSUBS sky130_fd_sc_hd__decap_3
Xsky130_fd_sc_hd__decap_3_145 VSUBS VSUBS VSUBS VSUBS sky130_fd_sc_hd__decap_3
Xsky130_fd_sc_hd__decap_3_134 VSUBS VSUBS VSUBS VSUBS sky130_fd_sc_hd__decap_3
Xsky130_fd_sc_hd__decap_3_167 VSUBS VSUBS VSUBS VSUBS sky130_fd_sc_hd__decap_3
Xsky130_fd_sc_hd__decap_3_156 VSUBS VSUBS VSUBS VSUBS sky130_fd_sc_hd__decap_3
Xsky130_fd_sc_hd__decap_3_112 VSUBS VSUBS VSUBS VSUBS sky130_fd_sc_hd__decap_3
Xsky130_fd_sc_hd__decap_3_123 VSUBS VSUBS VSUBS VSUBS sky130_fd_sc_hd__decap_3
Xsky130_fd_sc_hd__decap_3_101 VSUBS VSUBS VSUBS VSUBS sky130_fd_sc_hd__decap_3
Xsky130_fd_sc_hd__a21oi_1_6 VSUBS VSUBS VSUBS VSUBS VSUBS VSUBS VSUBS VSUBS VSUBS
+ sky130_fd_sc_hd__a21oi_1
Xsky130_fd_sc_hd__decap_12_250 VSUBS VSUBS VSUBS VSUBS sky130_fd_sc_hd__decap_12
Xsky130_fd_sc_hd__decap_12_261 VSUBS VSUBS VSUBS VSUBS sky130_fd_sc_hd__decap_12
Xsky130_fd_sc_hd__decap_12_283 VSUBS VSUBS VSUBS VSUBS sky130_fd_sc_hd__decap_12
Xsky130_fd_sc_hd__decap_12_294 VSUBS VSUBS VSUBS VSUBS sky130_fd_sc_hd__decap_12
Xsky130_fd_sc_hd__decap_12_272 VSUBS VSUBS VSUBS VSUBS sky130_fd_sc_hd__decap_12
Xsky130_fd_sc_hd__decap_6_6 VSUBS VSUBS VSUBS VSUBS sky130_fd_sc_hd__decap_6
Xsky130_fd_sc_hd__decap_8_259 VSUBS VSUBS VSUBS VSUBS sky130_fd_sc_hd__decap_8
Xsky130_fd_sc_hd__decap_8_248 VSUBS VSUBS VSUBS VSUBS sky130_fd_sc_hd__decap_8
Xsky130_fd_sc_hd__decap_8_226 VSUBS VSUBS VSUBS VSUBS sky130_fd_sc_hd__decap_8
Xsky130_fd_sc_hd__nand2b_1_3 VSUBS VSUBS VSUBS VSUBS VSUBS VSUBS VSUBS VSUBS sky130_fd_sc_hd__nand2b_1
Xsky130_fd_sc_hd__decap_8_237 VSUBS VSUBS VSUBS VSUBS sky130_fd_sc_hd__decap_8
Xsky130_fd_sc_hd__decap_8_215 VSUBS VSUBS VSUBS VSUBS sky130_fd_sc_hd__decap_8
Xsky130_fd_sc_hd__decap_8_204 VSUBS VSUBS VSUBS VSUBS sky130_fd_sc_hd__decap_8
Xsky130_fd_sc_hd__decap_6_82 VSUBS VSUBS VSUBS VSUBS sky130_fd_sc_hd__decap_6
Xsky130_fd_sc_hd__decap_6_71 VSUBS VSUBS VSUBS VSUBS sky130_fd_sc_hd__decap_6
Xsky130_fd_sc_hd__decap_6_93 VSUBS VSUBS VSUBS VSUBS sky130_fd_sc_hd__decap_6
Xsky130_fd_sc_hd__a21bo_1_0 VSUBS VSUBS VSUBS VSUBS VSUBS VSUBS VSUBS VSUBS VSUBS
+ VSUBS VSUBS sky130_fd_sc_hd__a21bo_1
Xsky130_fd_sc_hd__decap_6_60 VSUBS VSUBS VSUBS VSUBS sky130_fd_sc_hd__decap_6
Xsky130_fd_sc_hd__decap_12_1090 VSUBS VSUBS VSUBS VSUBS sky130_fd_sc_hd__decap_12
Xsky130_fd_sc_hd__decap_4_3 VSUBS VSUBS VSUBS VSUBS sky130_fd_sc_hd__decap_4
Xsky130_fd_sc_hd__conb_1_3 VSUBS VSUBS VSUBS VSUBS VSUBS VSUBS sky130_fd_sc_hd__conb_1_3/a_21_232#
+ sky130_fd_sc_hd__conb_1_3/a_159_232# sky130_fd_sc_hd__conb_1
Xsky130_fd_sc_hd__mux2i_1_0 VSUBS VSUBS VSUBS VSUBS VSUBS VSUBS VSUBS VSUBS VSUBS
+ VSUBS VSUBS VSUBS sky130_fd_sc_hd__mux2i_1
Xsky130_fd_sc_hd__a31oi_1_0 VSUBS VSUBS VSUBS VSUBS sky130_fd_sc_hd__a31oi_1_0/A3
+ VSUBS VSUBS VSUBS VSUBS sky130_fd_sc_hd__a31oi_1_0/a_181_47# VSUBS sky130_fd_sc_hd__a31oi_1
Xsky130_fd_sc_hd__decap_12_827 VSUBS VSUBS VSUBS VSUBS sky130_fd_sc_hd__decap_12
Xsky130_fd_sc_hd__decap_12_849 VSUBS VSUBS VSUBS VSUBS sky130_fd_sc_hd__decap_12
Xsky130_fd_sc_hd__decap_12_838 VSUBS VSUBS VSUBS VSUBS sky130_fd_sc_hd__decap_12
Xsky130_fd_sc_hd__decap_12_805 VSUBS VSUBS VSUBS VSUBS sky130_fd_sc_hd__decap_12
Xsky130_fd_sc_hd__decap_12_816 VSUBS VSUBS VSUBS VSUBS sky130_fd_sc_hd__decap_12
Xsky130_fd_sc_hd__decap_3_61 VSUBS VSUBS VSUBS VSUBS sky130_fd_sc_hd__decap_3
Xsky130_fd_sc_hd__decap_3_72 VSUBS VSUBS VSUBS VSUBS sky130_fd_sc_hd__decap_3
Xsky130_fd_sc_hd__decap_3_94 VSUBS VSUBS VSUBS VSUBS sky130_fd_sc_hd__decap_3
Xsky130_fd_sc_hd__decap_3_83 VSUBS VSUBS VSUBS VSUBS sky130_fd_sc_hd__decap_3
Xsky130_fd_sc_hd__decap_3_50 VSUBS VSUBS VSUBS VSUBS sky130_fd_sc_hd__decap_3
Xsky130_fd_sc_hd__decap_8_28 VSUBS VSUBS VSUBS VSUBS sky130_fd_sc_hd__decap_8
Xsky130_fd_sc_hd__decap_8_39 VSUBS VSUBS VSUBS VSUBS sky130_fd_sc_hd__decap_8
Xsky130_fd_sc_hd__decap_8_17 VSUBS VSUBS VSUBS VSUBS sky130_fd_sc_hd__decap_8
Xsky130_fd_sc_hd__xnor2_1_17 VSUBS VSUBS VSUBS VSUBS VSUBS VSUBS VSUBS VSUBS VSUBS
+ sky130_fd_sc_hd__xnor2_1_17/a_377_297# sky130_fd_sc_hd__xnor2_1
Xsky130_fd_sc_hd__decap_12_646 VSUBS VSUBS VSUBS VSUBS sky130_fd_sc_hd__decap_12
Xsky130_fd_sc_hd__decap_12_668 VSUBS VSUBS VSUBS VSUBS sky130_fd_sc_hd__decap_12
Xsky130_fd_sc_hd__decap_12_657 VSUBS VSUBS VSUBS VSUBS sky130_fd_sc_hd__decap_12
Xsky130_fd_sc_hd__decap_12_602 VSUBS VSUBS VSUBS VSUBS sky130_fd_sc_hd__decap_12
Xsky130_fd_sc_hd__decap_12_624 VSUBS VSUBS VSUBS VSUBS sky130_fd_sc_hd__decap_12
Xsky130_fd_sc_hd__decap_12_679 VSUBS VSUBS VSUBS VSUBS sky130_fd_sc_hd__decap_12
Xsky130_fd_sc_hd__decap_12_635 VSUBS VSUBS VSUBS VSUBS sky130_fd_sc_hd__decap_12
Xsky130_fd_sc_hd__decap_12_613 VSUBS VSUBS VSUBS VSUBS sky130_fd_sc_hd__decap_12
Xsky130_fd_sc_hd__o21ai_0_51 VSUBS VSUBS VSUBS VSUBS VSUBS VSUBS VSUBS VSUBS VSUBS
+ sky130_fd_sc_hd__o21ai_0
Xsky130_fd_sc_hd__o21ai_0_40 VSUBS VSUBS VSUBS VSUBS sky130_fd_sc_hd__nor2_1_53/A
+ VSUBS VSUBS VSUBS VSUBS sky130_fd_sc_hd__o21ai_0
Xsky130_fd_sc_hd__o21ai_0_62 VSUBS VSUBS VSUBS VSUBS sky130_fd_sc_hd__o21ai_0_62/B1
+ VSUBS sky130_fd_sc_hd__o21ai_0_62/Y VSUBS VSUBS sky130_fd_sc_hd__o21ai_0
Xsky130_fd_sc_hd__nand2_1_1 VSUBS VSUBS VSUBS VSUBS VSUBS VSUBS VSUBS sky130_fd_sc_hd__nand2_1
Xsky130_fd_sc_hd__a22oi_1_8 VSUBS VSUBS VSUBS VSUBS VSUBS VSUBS VSUBS VSUBS VSUBS
+ sky130_fd_sc_hd__a22oi_1_8/a_381_47# VSUBS sky130_fd_sc_hd__a22oi_1
Xsky130_fd_sc_hd__a21oi_1_50 VSUBS VSUBS VSUBS VSUBS VSUBS VSUBS VSUBS VSUBS VSUBS
+ sky130_fd_sc_hd__a21oi_1
Xsky130_fd_sc_hd__decap_6_110 VSUBS VSUBS VSUBS VSUBS sky130_fd_sc_hd__decap_6
Xsky130_fd_sc_hd__decap_12_90 VSUBS VSUBS VSUBS VSUBS sky130_fd_sc_hd__decap_12
Xsky130_fd_sc_hd__decap_12_410 VSUBS VSUBS VSUBS VSUBS sky130_fd_sc_hd__decap_12
Xsky130_fd_sc_hd__decap_12_432 VSUBS VSUBS VSUBS VSUBS sky130_fd_sc_hd__decap_12
Xsky130_fd_sc_hd__decap_12_421 VSUBS VSUBS VSUBS VSUBS sky130_fd_sc_hd__decap_12
Xsky130_fd_sc_hd__decap_12_443 VSUBS VSUBS VSUBS VSUBS sky130_fd_sc_hd__decap_12
Xsky130_fd_sc_hd__decap_12_476 VSUBS VSUBS VSUBS VSUBS sky130_fd_sc_hd__decap_12
Xsky130_fd_sc_hd__decap_12_487 VSUBS VSUBS VSUBS VSUBS sky130_fd_sc_hd__decap_12
Xsky130_fd_sc_hd__decap_12_465 VSUBS VSUBS VSUBS VSUBS sky130_fd_sc_hd__decap_12
Xsky130_fd_sc_hd__decap_12_498 VSUBS VSUBS VSUBS VSUBS sky130_fd_sc_hd__decap_12
Xsky130_fd_sc_hd__decap_12_454 VSUBS VSUBS VSUBS VSUBS sky130_fd_sc_hd__decap_12
Xsky130_fd_sc_hd__decap_3_179 VSUBS VSUBS VSUBS VSUBS sky130_fd_sc_hd__decap_3
Xsky130_fd_sc_hd__decap_3_146 VSUBS VSUBS VSUBS VSUBS sky130_fd_sc_hd__decap_3
Xsky130_fd_sc_hd__decap_3_135 VSUBS VSUBS VSUBS VSUBS sky130_fd_sc_hd__decap_3
Xsky130_fd_sc_hd__decap_3_168 VSUBS VSUBS VSUBS VSUBS sky130_fd_sc_hd__decap_3
Xsky130_fd_sc_hd__decap_3_157 VSUBS VSUBS VSUBS VSUBS sky130_fd_sc_hd__decap_3
Xsky130_fd_sc_hd__decap_3_124 VSUBS VSUBS VSUBS VSUBS sky130_fd_sc_hd__decap_3
Xsky130_fd_sc_hd__decap_3_113 VSUBS VSUBS VSUBS VSUBS sky130_fd_sc_hd__decap_3
Xsky130_fd_sc_hd__decap_3_102 VSUBS VSUBS VSUBS VSUBS sky130_fd_sc_hd__decap_3
Xsky130_fd_sc_hd__a21oi_1_7 VSUBS VSUBS VSUBS VSUBS VSUBS VSUBS VSUBS VSUBS VSUBS
+ sky130_fd_sc_hd__a21oi_1
Xsky130_fd_sc_hd__decap_12_273 VSUBS VSUBS VSUBS VSUBS sky130_fd_sc_hd__decap_12
Xsky130_fd_sc_hd__decap_12_284 VSUBS VSUBS VSUBS VSUBS sky130_fd_sc_hd__decap_12
Xsky130_fd_sc_hd__decap_12_251 VSUBS VSUBS VSUBS VSUBS sky130_fd_sc_hd__decap_12
Xsky130_fd_sc_hd__decap_12_262 VSUBS VSUBS VSUBS VSUBS sky130_fd_sc_hd__decap_12
Xsky130_fd_sc_hd__decap_12_240 VSUBS VSUBS VSUBS VSUBS sky130_fd_sc_hd__decap_12
Xsky130_fd_sc_hd__decap_12_295 VSUBS VSUBS VSUBS VSUBS sky130_fd_sc_hd__decap_12
Xsky130_fd_sc_hd__decap_6_7 VSUBS VSUBS VSUBS VSUBS sky130_fd_sc_hd__decap_6
Xsky130_fd_sc_hd__xor2_1_10 VSUBS VSUBS VSUBS VSUBS VSUBS VSUBS VSUBS VSUBS VSUBS
+ sky130_fd_sc_hd__xor2_1
Xsky130_fd_sc_hd__decap_8_216 VSUBS VSUBS VSUBS VSUBS sky130_fd_sc_hd__decap_8
Xsky130_fd_sc_hd__decap_8_205 VSUBS VSUBS VSUBS VSUBS sky130_fd_sc_hd__decap_8
Xsky130_fd_sc_hd__decap_8_227 VSUBS VSUBS VSUBS VSUBS sky130_fd_sc_hd__decap_8
Xsky130_fd_sc_hd__decap_8_249 VSUBS VSUBS VSUBS VSUBS sky130_fd_sc_hd__decap_8
Xsky130_fd_sc_hd__decap_8_238 VSUBS VSUBS VSUBS VSUBS sky130_fd_sc_hd__decap_8
Xsky130_fd_sc_hd__nand2b_1_4 VSUBS VSUBS VSUBS VSUBS VSUBS VSUBS VSUBS VSUBS sky130_fd_sc_hd__nand2b_1
Xsky130_fd_sc_hd__decap_6_72 VSUBS VSUBS VSUBS VSUBS sky130_fd_sc_hd__decap_6
Xsky130_fd_sc_hd__decap_6_83 VSUBS VSUBS VSUBS VSUBS sky130_fd_sc_hd__decap_6
Xsky130_fd_sc_hd__decap_6_94 VSUBS VSUBS VSUBS VSUBS sky130_fd_sc_hd__decap_6
Xsky130_fd_sc_hd__decap_6_61 VSUBS VSUBS VSUBS VSUBS sky130_fd_sc_hd__decap_6
Xsky130_fd_sc_hd__decap_6_50 VSUBS VSUBS VSUBS VSUBS sky130_fd_sc_hd__decap_6
Xsky130_fd_sc_hd__clkinv_1_0 VSUBS VSUBS VSUBS VSUBS VSUBS VSUBS sky130_fd_sc_hd__clkinv_1
Xsky130_fd_sc_hd__decap_12_1080 VSUBS VSUBS VSUBS VSUBS sky130_fd_sc_hd__decap_12
Xsky130_fd_sc_hd__decap_12_1091 VSUBS VSUBS VSUBS VSUBS sky130_fd_sc_hd__decap_12
Xsky130_fd_sc_hd__decap_4_4 VSUBS VSUBS VSUBS VSUBS sky130_fd_sc_hd__decap_4
Xsky130_fd_sc_hd__dfxtp_1_90 VSUBS VSUBS VSUBS VSUBS sky130_fd_sc_hd__dfxtp_1_90/CLK
+ VSUBS VSUBS sky130_fd_sc_hd__dfxtp_1_90/a_975_413# VSUBS VSUBS sky130_fd_sc_hd__dfxtp_1_90/a_592_47#
+ VSUBS VSUBS sky130_fd_sc_hd__dfxtp_1_90/a_561_413# VSUBS VSUBS VSUBS sky130_fd_sc_hd__dfxtp_1
Xsky130_fd_sc_hd__conb_1_4 VSUBS VSUBS VSUBS VSUBS VSUBS VSUBS sky130_fd_sc_hd__conb_1_4/a_21_232#
+ sky130_fd_sc_hd__conb_1_4/a_159_232# sky130_fd_sc_hd__conb_1
Xsky130_fd_sc_hd__mux2i_1_1 VSUBS VSUBS VSUBS VSUBS VSUBS sky130_fd_sc_hd__mux2i_1_1/Y
+ VSUBS VSUBS VSUBS VSUBS VSUBS VSUBS sky130_fd_sc_hd__mux2i_1
Xsky130_fd_sc_hd__a31oi_1_1 VSUBS VSUBS VSUBS VSUBS VSUBS VSUBS VSUBS VSUBS VSUBS
+ VSUBS VSUBS sky130_fd_sc_hd__a31oi_1
Xsky130_fd_sc_hd__decap_12_839 VSUBS VSUBS VSUBS VSUBS sky130_fd_sc_hd__decap_12
Xsky130_fd_sc_hd__decap_12_828 VSUBS VSUBS VSUBS VSUBS sky130_fd_sc_hd__decap_12
Xsky130_fd_sc_hd__decap_12_806 VSUBS VSUBS VSUBS VSUBS sky130_fd_sc_hd__decap_12
Xsky130_fd_sc_hd__decap_12_817 VSUBS VSUBS VSUBS VSUBS sky130_fd_sc_hd__decap_12
Xsky130_fd_sc_hd__decap_3_62 VSUBS VSUBS VSUBS VSUBS sky130_fd_sc_hd__decap_3
Xsky130_fd_sc_hd__decap_3_73 VSUBS VSUBS VSUBS VSUBS sky130_fd_sc_hd__decap_3
Xsky130_fd_sc_hd__decap_3_84 VSUBS VSUBS VSUBS VSUBS sky130_fd_sc_hd__decap_3
Xsky130_fd_sc_hd__decap_3_40 VSUBS VSUBS VSUBS VSUBS sky130_fd_sc_hd__decap_3
Xsky130_fd_sc_hd__decap_3_95 VSUBS VSUBS VSUBS VSUBS sky130_fd_sc_hd__decap_3
Xsky130_fd_sc_hd__decap_3_51 VSUBS VSUBS VSUBS VSUBS sky130_fd_sc_hd__decap_3
Xsky130_fd_sc_hd__decap_8_29 VSUBS VSUBS VSUBS VSUBS sky130_fd_sc_hd__decap_8
Xsky130_fd_sc_hd__decap_8_18 VSUBS VSUBS VSUBS VSUBS sky130_fd_sc_hd__decap_8
Xsky130_fd_sc_hd__edfxtp_1_0 VSUBS VSUBS VSUBS VSUBS VSUBS VSUBS VSUBS VSUBS sky130_fd_sc_hd__edfxtp_1_0/a_1717_47#
+ sky130_fd_sc_hd__edfxtp_1_0/a_1514_47# VSUBS sky130_fd_sc_hd__edfxtp_1_0/a_1500_413#
+ sky130_fd_sc_hd__edfxtp_1_0/a_729_47# VSUBS VSUBS VSUBS VSUBS sky130_fd_sc_hd__edfxtp_1_0/a_729_369#
+ VSUBS sky130_fd_sc_hd__edfxtp_1_0/a_1675_413# VSUBS VSUBS sky130_fd_sc_hd__edfxtp_1
Xsky130_fd_sc_hd__decap_12_603 VSUBS VSUBS VSUBS VSUBS sky130_fd_sc_hd__decap_12
Xsky130_fd_sc_hd__decap_12_625 VSUBS VSUBS VSUBS VSUBS sky130_fd_sc_hd__decap_12
Xsky130_fd_sc_hd__decap_12_614 VSUBS VSUBS VSUBS VSUBS sky130_fd_sc_hd__decap_12
Xsky130_fd_sc_hd__xnor2_1_18 VSUBS VSUBS VSUBS VSUBS VSUBS VSUBS VSUBS VSUBS VSUBS
+ sky130_fd_sc_hd__xnor2_1_18/a_377_297# sky130_fd_sc_hd__xnor2_1
Xsky130_fd_sc_hd__decap_12_658 VSUBS VSUBS VSUBS VSUBS sky130_fd_sc_hd__decap_12
Xsky130_fd_sc_hd__decap_12_647 VSUBS VSUBS VSUBS VSUBS sky130_fd_sc_hd__decap_12
Xsky130_fd_sc_hd__decap_12_669 VSUBS VSUBS VSUBS VSUBS sky130_fd_sc_hd__decap_12
Xsky130_fd_sc_hd__decap_12_636 VSUBS VSUBS VSUBS VSUBS sky130_fd_sc_hd__decap_12
Xsky130_fd_sc_hd__nor2b_1_0 VSUBS VSUBS VSUBS VSUBS VSUBS VSUBS VSUBS VSUBS sky130_fd_sc_hd__nor2b_1
Xsky130_fd_sc_hd__o21ai_0_30 VSUBS VSUBS VSUBS VSUBS sky130_fd_sc_hd__o21ai_0_30/B1
+ VSUBS VSUBS VSUBS VSUBS sky130_fd_sc_hd__o21ai_0
Xsky130_fd_sc_hd__o21ai_0_52 VSUBS VSUBS VSUBS VSUBS VSUBS VSUBS VSUBS sky130_fd_sc_hd__o21ai_0_52/A2
+ VSUBS sky130_fd_sc_hd__o21ai_0
Xsky130_fd_sc_hd__o21ai_0_41 VSUBS VSUBS VSUBS VSUBS VSUBS VSUBS VSUBS VSUBS VSUBS
+ sky130_fd_sc_hd__o21ai_0
Xsky130_fd_sc_hd__o21ai_0_63 VSUBS VSUBS VSUBS VSUBS VSUBS VSUBS VSUBS VSUBS VSUBS
+ sky130_fd_sc_hd__o21ai_0
Xsky130_fd_sc_hd__nand2_1_2 VSUBS VSUBS VSUBS VSUBS VSUBS VSUBS VSUBS sky130_fd_sc_hd__nand2_1
Xsky130_fd_sc_hd__a22oi_1_9 VSUBS VSUBS VSUBS VSUBS VSUBS VSUBS VSUBS VSUBS VSUBS
+ sky130_fd_sc_hd__a22oi_1_9/a_381_47# VSUBS sky130_fd_sc_hd__a22oi_1
Xsky130_fd_sc_hd__a21oi_1_40 VSUBS VSUBS VSUBS VSUBS sky130_fd_sc_hd__a21oi_1_40/A2
+ VSUBS VSUBS VSUBS VSUBS sky130_fd_sc_hd__a21oi_1
Xsky130_fd_sc_hd__a21oi_1_51 VSUBS VSUBS VSUBS VSUBS VSUBS VSUBS VSUBS VSUBS VSUBS
+ sky130_fd_sc_hd__a21oi_1
Xsky130_fd_sc_hd__decap_6_111 VSUBS VSUBS VSUBS VSUBS sky130_fd_sc_hd__decap_6
Xsky130_fd_sc_hd__decap_6_100 VSUBS VSUBS VSUBS VSUBS sky130_fd_sc_hd__decap_6
Xsky130_fd_sc_hd__decap_12_91 VSUBS VSUBS VSUBS VSUBS sky130_fd_sc_hd__decap_12
Xsky130_fd_sc_hd__decap_12_80 VSUBS VSUBS VSUBS VSUBS sky130_fd_sc_hd__decap_12
Xsky130_fd_sc_hd__decap_12_477 VSUBS VSUBS VSUBS VSUBS sky130_fd_sc_hd__decap_12
Xsky130_fd_sc_hd__decap_12_400 VSUBS VSUBS VSUBS VSUBS sky130_fd_sc_hd__decap_12
Xsky130_fd_sc_hd__decap_12_411 VSUBS VSUBS VSUBS VSUBS sky130_fd_sc_hd__decap_12
Xsky130_fd_sc_hd__decap_12_455 VSUBS VSUBS VSUBS VSUBS sky130_fd_sc_hd__decap_12
Xsky130_fd_sc_hd__decap_12_433 VSUBS VSUBS VSUBS VSUBS sky130_fd_sc_hd__decap_12
Xsky130_fd_sc_hd__decap_12_466 VSUBS VSUBS VSUBS VSUBS sky130_fd_sc_hd__decap_12
Xsky130_fd_sc_hd__decap_12_444 VSUBS VSUBS VSUBS VSUBS sky130_fd_sc_hd__decap_12
Xsky130_fd_sc_hd__decap_12_422 VSUBS VSUBS VSUBS VSUBS sky130_fd_sc_hd__decap_12
Xsky130_fd_sc_hd__decap_12_488 VSUBS VSUBS VSUBS VSUBS sky130_fd_sc_hd__decap_12
Xsky130_fd_sc_hd__decap_12_499 VSUBS VSUBS VSUBS VSUBS sky130_fd_sc_hd__decap_12
Xsky130_fd_sc_hd__decap_3_114 VSUBS VSUBS VSUBS VSUBS sky130_fd_sc_hd__decap_3
Xsky130_fd_sc_hd__decap_3_125 VSUBS VSUBS VSUBS VSUBS sky130_fd_sc_hd__decap_3
Xsky130_fd_sc_hd__decap_3_103 VSUBS VSUBS VSUBS VSUBS sky130_fd_sc_hd__decap_3
Xsky130_fd_sc_hd__decap_3_136 VSUBS VSUBS VSUBS VSUBS sky130_fd_sc_hd__decap_3
Xsky130_fd_sc_hd__decap_3_147 VSUBS VSUBS VSUBS VSUBS sky130_fd_sc_hd__decap_3
Xsky130_fd_sc_hd__decap_3_169 VSUBS VSUBS VSUBS VSUBS sky130_fd_sc_hd__decap_3
Xsky130_fd_sc_hd__decap_3_158 VSUBS VSUBS VSUBS VSUBS sky130_fd_sc_hd__decap_3
Xsky130_fd_sc_hd__a21oi_1_8 VSUBS VSUBS VSUBS VSUBS VSUBS VSUBS VSUBS VSUBS VSUBS
+ sky130_fd_sc_hd__a21oi_1
Xsky130_fd_sc_hd__decap_12_285 VSUBS VSUBS VSUBS VSUBS sky130_fd_sc_hd__decap_12
Xsky130_fd_sc_hd__decap_12_230 VSUBS VSUBS VSUBS VSUBS sky130_fd_sc_hd__decap_12
Xsky130_fd_sc_hd__decap_12_296 VSUBS VSUBS VSUBS VSUBS sky130_fd_sc_hd__decap_12
Xsky130_fd_sc_hd__decap_12_241 VSUBS VSUBS VSUBS VSUBS sky130_fd_sc_hd__decap_12
Xsky130_fd_sc_hd__decap_12_252 VSUBS VSUBS VSUBS VSUBS sky130_fd_sc_hd__decap_12
Xsky130_fd_sc_hd__decap_12_274 VSUBS VSUBS VSUBS VSUBS sky130_fd_sc_hd__decap_12
Xsky130_fd_sc_hd__decap_12_263 VSUBS VSUBS VSUBS VSUBS sky130_fd_sc_hd__decap_12
Xsky130_fd_sc_hd__decap_6_8 VSUBS VSUBS VSUBS VSUBS sky130_fd_sc_hd__decap_6
Xsky130_fd_sc_hd__decap_8_228 VSUBS VSUBS VSUBS VSUBS sky130_fd_sc_hd__decap_8
Xsky130_fd_sc_hd__xor2_1_11 VSUBS VSUBS VSUBS VSUBS VSUBS VSUBS VSUBS VSUBS VSUBS
+ sky130_fd_sc_hd__xor2_1
Xsky130_fd_sc_hd__decap_8_239 VSUBS VSUBS VSUBS VSUBS sky130_fd_sc_hd__decap_8
Xsky130_fd_sc_hd__decap_8_217 VSUBS VSUBS VSUBS VSUBS sky130_fd_sc_hd__decap_8
Xsky130_fd_sc_hd__decap_8_206 VSUBS VSUBS VSUBS VSUBS sky130_fd_sc_hd__decap_8
Xsky130_fd_sc_hd__nand2b_1_5 VSUBS VSUBS VSUBS VSUBS VSUBS VSUBS VSUBS VSUBS sky130_fd_sc_hd__nand2b_1
Xsky130_fd_sc_hd__decap_6_73 VSUBS VSUBS VSUBS VSUBS sky130_fd_sc_hd__decap_6
Xsky130_fd_sc_hd__decap_6_84 VSUBS VSUBS VSUBS VSUBS sky130_fd_sc_hd__decap_6
Xsky130_fd_sc_hd__decap_6_95 VSUBS VSUBS VSUBS VSUBS sky130_fd_sc_hd__decap_6
Xsky130_fd_sc_hd__decap_6_62 VSUBS VSUBS VSUBS VSUBS sky130_fd_sc_hd__decap_6
Xsky130_fd_sc_hd__decap_6_40 VSUBS VSUBS VSUBS VSUBS sky130_fd_sc_hd__decap_6
Xsky130_fd_sc_hd__decap_6_51 VSUBS VSUBS VSUBS VSUBS sky130_fd_sc_hd__decap_6
Xsky130_fd_sc_hd__clkinv_1_1 VSUBS VSUBS VSUBS VSUBS VSUBS VSUBS sky130_fd_sc_hd__clkinv_1
Xsky130_fd_sc_hd__decap_12_1081 VSUBS VSUBS VSUBS VSUBS sky130_fd_sc_hd__decap_12
Xsky130_fd_sc_hd__decap_12_1070 VSUBS VSUBS VSUBS VSUBS sky130_fd_sc_hd__decap_12
Xsky130_fd_sc_hd__decap_12_1092 VSUBS VSUBS VSUBS VSUBS sky130_fd_sc_hd__decap_12
Xsky130_fd_sc_hd__decap_4_5 VSUBS VSUBS VSUBS VSUBS sky130_fd_sc_hd__decap_4
Xsky130_fd_sc_hd__dfxtp_1_80 VSUBS VSUBS VSUBS VSUBS VSUBS VSUBS VSUBS sky130_fd_sc_hd__dfxtp_1_80/a_975_413#
+ VSUBS VSUBS sky130_fd_sc_hd__dfxtp_1_80/a_592_47# VSUBS VSUBS sky130_fd_sc_hd__dfxtp_1_80/a_561_413#
+ VSUBS VSUBS VSUBS sky130_fd_sc_hd__dfxtp_1
Xsky130_fd_sc_hd__dfxtp_1_91 VSUBS VSUBS VSUBS VSUBS sky130_fd_sc_hd__dfxtp_1_91/CLK
+ VSUBS VSUBS sky130_fd_sc_hd__dfxtp_1_91/a_975_413# VSUBS VSUBS sky130_fd_sc_hd__dfxtp_1_91/a_592_47#
+ VSUBS VSUBS sky130_fd_sc_hd__dfxtp_1_91/a_561_413# VSUBS VSUBS VSUBS sky130_fd_sc_hd__dfxtp_1
Xsky130_fd_sc_hd__mux2i_1_2 VSUBS VSUBS VSUBS VSUBS VSUBS VSUBS VSUBS VSUBS VSUBS
+ VSUBS VSUBS VSUBS sky130_fd_sc_hd__mux2i_1
Xsky130_fd_sc_hd__conb_1_5 VSUBS VSUBS VSUBS VSUBS VSUBS VSUBS sky130_fd_sc_hd__conb_1_5/a_21_232#
+ sky130_fd_sc_hd__conb_1_5/a_159_232# sky130_fd_sc_hd__conb_1
Xsky130_fd_sc_hd__a31oi_1_2 VSUBS VSUBS VSUBS VSUBS VSUBS sky130_fd_sc_hd__a31oi_1_2/A2
+ sky130_fd_sc_hd__a31oi_1_2/A2 VSUBS VSUBS sky130_fd_sc_hd__a31oi_1_2/a_181_47# VSUBS
+ sky130_fd_sc_hd__a31oi_1
Xsky130_fd_sc_hd__decap_12_807 VSUBS VSUBS VSUBS VSUBS sky130_fd_sc_hd__decap_12
Xsky130_fd_sc_hd__decap_12_818 VSUBS VSUBS VSUBS VSUBS sky130_fd_sc_hd__decap_12
Xsky130_fd_sc_hd__decap_3_63 VSUBS VSUBS VSUBS VSUBS sky130_fd_sc_hd__decap_3
Xsky130_fd_sc_hd__decap_3_30 VSUBS VSUBS VSUBS VSUBS sky130_fd_sc_hd__decap_3
Xsky130_fd_sc_hd__decap_3_41 VSUBS VSUBS VSUBS VSUBS sky130_fd_sc_hd__decap_3
Xsky130_fd_sc_hd__decap_3_52 VSUBS VSUBS VSUBS VSUBS sky130_fd_sc_hd__decap_3
Xsky130_fd_sc_hd__decap_12_829 VSUBS VSUBS VSUBS VSUBS sky130_fd_sc_hd__decap_12
Xsky130_fd_sc_hd__decap_3_74 VSUBS VSUBS VSUBS VSUBS sky130_fd_sc_hd__decap_3
Xsky130_fd_sc_hd__decap_3_96 VSUBS VSUBS VSUBS VSUBS sky130_fd_sc_hd__decap_3
Xsky130_fd_sc_hd__decap_3_85 VSUBS VSUBS VSUBS VSUBS sky130_fd_sc_hd__decap_3
Xsky130_fd_sc_hd__decap_8_19 VSUBS VSUBS VSUBS VSUBS sky130_fd_sc_hd__decap_8
Xsky130_fd_sc_hd__edfxtp_1_1 VSUBS VSUBS VSUBS VSUBS VSUBS VSUBS VSUBS sky130_fd_sc_hd__edfxtp_1_1/D
+ sky130_fd_sc_hd__edfxtp_1_1/a_1717_47# sky130_fd_sc_hd__edfxtp_1_1/a_1514_47# VSUBS
+ sky130_fd_sc_hd__edfxtp_1_1/a_1500_413# VSUBS VSUBS VSUBS VSUBS VSUBS VSUBS VSUBS
+ sky130_fd_sc_hd__edfxtp_1_1/a_1675_413# VSUBS VSUBS sky130_fd_sc_hd__edfxtp_1
Xsky130_fd_sc_hd__xnor2_1_19 VSUBS VSUBS VSUBS VSUBS VSUBS VSUBS VSUBS VSUBS VSUBS
+ sky130_fd_sc_hd__xnor2_1_19/a_377_297# sky130_fd_sc_hd__xnor2_1
Xsky130_fd_sc_hd__decap_12_659 VSUBS VSUBS VSUBS VSUBS sky130_fd_sc_hd__decap_12
Xsky130_fd_sc_hd__decap_12_648 VSUBS VSUBS VSUBS VSUBS sky130_fd_sc_hd__decap_12
Xsky130_fd_sc_hd__decap_12_604 VSUBS VSUBS VSUBS VSUBS sky130_fd_sc_hd__decap_12
Xsky130_fd_sc_hd__decap_12_615 VSUBS VSUBS VSUBS VSUBS sky130_fd_sc_hd__decap_12
Xsky130_fd_sc_hd__decap_12_626 VSUBS VSUBS VSUBS VSUBS sky130_fd_sc_hd__decap_12
Xsky130_fd_sc_hd__decap_12_637 VSUBS VSUBS VSUBS VSUBS sky130_fd_sc_hd__decap_12
Xsky130_fd_sc_hd__o21ai_0_64 VSUBS VSUBS VSUBS VSUBS VSUBS VSUBS VSUBS VSUBS VSUBS
+ sky130_fd_sc_hd__o21ai_0
Xsky130_fd_sc_hd__o21ai_0_31 VSUBS VSUBS VSUBS VSUBS VSUBS VSUBS VSUBS VSUBS VSUBS
+ sky130_fd_sc_hd__o21ai_0
Xsky130_fd_sc_hd__o21ai_0_53 VSUBS VSUBS VSUBS VSUBS sky130_fd_sc_hd__nor2_1_68/A
+ VSUBS VSUBS VSUBS VSUBS sky130_fd_sc_hd__o21ai_0
Xsky130_fd_sc_hd__o21ai_0_42 VSUBS VSUBS VSUBS VSUBS VSUBS VSUBS VSUBS VSUBS VSUBS
+ sky130_fd_sc_hd__o21ai_0
Xsky130_fd_sc_hd__nand2_1_3 VSUBS VSUBS VSUBS VSUBS VSUBS VSUBS VSUBS sky130_fd_sc_hd__nand2_1
Xsky130_fd_sc_hd__o21ai_0_20 VSUBS VSUBS VSUBS VSUBS sky130_fd_sc_hd__o21ai_0_20/B1
+ VSUBS VSUBS VSUBS VSUBS sky130_fd_sc_hd__o21ai_0
Xsky130_fd_sc_hd__a21oi_1_30 VSUBS VSUBS VSUBS VSUBS VSUBS VSUBS VSUBS VSUBS VSUBS
+ sky130_fd_sc_hd__a21oi_1
Xsky130_fd_sc_hd__a21oi_1_41 VSUBS VSUBS VSUBS VSUBS VSUBS VSUBS VSUBS VSUBS VSUBS
+ sky130_fd_sc_hd__a21oi_1
Xsky130_fd_sc_hd__a21oi_1_52 VSUBS VSUBS VSUBS VSUBS VSUBS VSUBS VSUBS VSUBS VSUBS
+ sky130_fd_sc_hd__a21oi_1
Xsky130_fd_sc_hd__nor3_1_0 VSUBS VSUBS VSUBS VSUBS VSUBS VSUBS VSUBS VSUBS sky130_fd_sc_hd__nor3_1
Xsky130_fd_sc_hd__decap_6_112 VSUBS VSUBS VSUBS VSUBS sky130_fd_sc_hd__decap_6
Xsky130_fd_sc_hd__decap_6_101 VSUBS VSUBS VSUBS VSUBS sky130_fd_sc_hd__decap_6
Xsky130_fd_sc_hd__decap_12_70 VSUBS VSUBS VSUBS VSUBS sky130_fd_sc_hd__decap_12
Xsky130_fd_sc_hd__decap_12_92 VSUBS VSUBS VSUBS VSUBS sky130_fd_sc_hd__decap_12
Xsky130_fd_sc_hd__decap_12_81 VSUBS VSUBS VSUBS VSUBS sky130_fd_sc_hd__decap_12
Xsky130_fd_sc_hd__decap_12_489 VSUBS VSUBS VSUBS VSUBS sky130_fd_sc_hd__decap_12
Xsky130_fd_sc_hd__decap_12_478 VSUBS VSUBS VSUBS VSUBS sky130_fd_sc_hd__decap_12
Xsky130_fd_sc_hd__decap_12_412 VSUBS VSUBS VSUBS VSUBS sky130_fd_sc_hd__decap_12
Xsky130_fd_sc_hd__decap_12_467 VSUBS VSUBS VSUBS VSUBS sky130_fd_sc_hd__decap_12
Xsky130_fd_sc_hd__decap_12_401 VSUBS VSUBS VSUBS VSUBS sky130_fd_sc_hd__decap_12
Xsky130_fd_sc_hd__decap_12_456 VSUBS VSUBS VSUBS VSUBS sky130_fd_sc_hd__decap_12
Xsky130_fd_sc_hd__decap_12_434 VSUBS VSUBS VSUBS VSUBS sky130_fd_sc_hd__decap_12
Xsky130_fd_sc_hd__decap_12_445 VSUBS VSUBS VSUBS VSUBS sky130_fd_sc_hd__decap_12
Xsky130_fd_sc_hd__decap_12_423 VSUBS VSUBS VSUBS VSUBS sky130_fd_sc_hd__decap_12
Xsky130_fd_sc_hd__decap_3_137 VSUBS VSUBS VSUBS VSUBS sky130_fd_sc_hd__decap_3
Xsky130_fd_sc_hd__decap_3_148 VSUBS VSUBS VSUBS VSUBS sky130_fd_sc_hd__decap_3
Xsky130_fd_sc_hd__decap_12_990 VSUBS VSUBS VSUBS VSUBS sky130_fd_sc_hd__decap_12
Xsky130_fd_sc_hd__decap_3_126 VSUBS VSUBS VSUBS VSUBS sky130_fd_sc_hd__decap_3
Xsky130_fd_sc_hd__decap_3_115 VSUBS VSUBS VSUBS VSUBS sky130_fd_sc_hd__decap_3
Xsky130_fd_sc_hd__decap_3_159 VSUBS VSUBS VSUBS VSUBS sky130_fd_sc_hd__decap_3
Xsky130_fd_sc_hd__decap_3_104 VSUBS VSUBS VSUBS VSUBS sky130_fd_sc_hd__decap_3
Xsky130_fd_sc_hd__a21oi_1_9 VSUBS VSUBS VSUBS VSUBS VSUBS VSUBS VSUBS VSUBS VSUBS
+ sky130_fd_sc_hd__a21oi_1
Xsky130_fd_sc_hd__decap_12_286 VSUBS VSUBS VSUBS VSUBS sky130_fd_sc_hd__decap_12
Xsky130_fd_sc_hd__decap_12_220 VSUBS VSUBS VSUBS VSUBS sky130_fd_sc_hd__decap_12
Xsky130_fd_sc_hd__decap_12_231 VSUBS VSUBS VSUBS VSUBS sky130_fd_sc_hd__decap_12
Xsky130_fd_sc_hd__decap_12_297 VSUBS VSUBS VSUBS VSUBS sky130_fd_sc_hd__decap_12
Xsky130_fd_sc_hd__decap_12_275 VSUBS VSUBS VSUBS VSUBS sky130_fd_sc_hd__decap_12
Xsky130_fd_sc_hd__decap_12_253 VSUBS VSUBS VSUBS VSUBS sky130_fd_sc_hd__decap_12
Xsky130_fd_sc_hd__decap_12_242 VSUBS VSUBS VSUBS VSUBS sky130_fd_sc_hd__decap_12
Xsky130_fd_sc_hd__decap_12_264 VSUBS VSUBS VSUBS VSUBS sky130_fd_sc_hd__decap_12
Xsky130_fd_sc_hd__decap_6_9 VSUBS VSUBS VSUBS VSUBS sky130_fd_sc_hd__decap_6
Xsky130_fd_sc_hd__decap_8_229 VSUBS VSUBS VSUBS VSUBS sky130_fd_sc_hd__decap_8
Xsky130_fd_sc_hd__xor2_1_12 VSUBS VSUBS VSUBS VSUBS VSUBS VSUBS VSUBS VSUBS VSUBS
+ sky130_fd_sc_hd__xor2_1
Xsky130_fd_sc_hd__decap_8_218 VSUBS VSUBS VSUBS VSUBS sky130_fd_sc_hd__decap_8
Xsky130_fd_sc_hd__decap_8_207 VSUBS VSUBS VSUBS VSUBS sky130_fd_sc_hd__decap_8
Xsky130_fd_sc_hd__decap_6_30 VSUBS VSUBS VSUBS VSUBS sky130_fd_sc_hd__decap_6
Xsky130_fd_sc_hd__decap_6_41 VSUBS VSUBS VSUBS VSUBS sky130_fd_sc_hd__decap_6
Xsky130_fd_sc_hd__decap_6_74 VSUBS VSUBS VSUBS VSUBS sky130_fd_sc_hd__decap_6
Xsky130_fd_sc_hd__decap_6_96 VSUBS VSUBS VSUBS VSUBS sky130_fd_sc_hd__decap_6
Xsky130_fd_sc_hd__decap_6_63 VSUBS VSUBS VSUBS VSUBS sky130_fd_sc_hd__decap_6
Xsky130_fd_sc_hd__decap_6_85 VSUBS VSUBS VSUBS VSUBS sky130_fd_sc_hd__decap_6
Xsky130_fd_sc_hd__decap_6_52 VSUBS VSUBS VSUBS VSUBS sky130_fd_sc_hd__decap_6
Xsky130_fd_sc_hd__clkinv_1_2 VSUBS VSUBS VSUBS VSUBS VSUBS VSUBS sky130_fd_sc_hd__clkinv_1
Xsky130_fd_sc_hd__decap_12_1071 VSUBS VSUBS VSUBS VSUBS sky130_fd_sc_hd__decap_12
Xsky130_fd_sc_hd__decap_12_1082 VSUBS VSUBS VSUBS VSUBS sky130_fd_sc_hd__decap_12
Xsky130_fd_sc_hd__decap_12_1060 VSUBS VSUBS VSUBS VSUBS sky130_fd_sc_hd__decap_12
Xsky130_fd_sc_hd__decap_12_1093 VSUBS VSUBS VSUBS VSUBS sky130_fd_sc_hd__decap_12
Xsky130_fd_sc_hd__decap_4_6 VSUBS VSUBS VSUBS VSUBS sky130_fd_sc_hd__decap_4
Xsky130_fd_sc_hd__dfxtp_1_81 VSUBS VSUBS VSUBS VSUBS VSUBS VSUBS VSUBS sky130_fd_sc_hd__dfxtp_1_81/a_975_413#
+ VSUBS VSUBS sky130_fd_sc_hd__dfxtp_1_81/a_592_47# VSUBS VSUBS sky130_fd_sc_hd__dfxtp_1_81/a_561_413#
+ VSUBS VSUBS VSUBS sky130_fd_sc_hd__dfxtp_1
Xsky130_fd_sc_hd__dfxtp_1_70 VSUBS VSUBS VSUBS VSUBS VSUBS VSUBS VSUBS sky130_fd_sc_hd__dfxtp_1_70/a_975_413#
+ VSUBS VSUBS sky130_fd_sc_hd__dfxtp_1_70/a_592_47# VSUBS VSUBS sky130_fd_sc_hd__dfxtp_1_70/a_561_413#
+ VSUBS VSUBS VSUBS sky130_fd_sc_hd__dfxtp_1
Xsky130_fd_sc_hd__dfxtp_1_92 VSUBS VSUBS VSUBS VSUBS VSUBS VSUBS VSUBS sky130_fd_sc_hd__dfxtp_1_92/a_975_413#
+ VSUBS VSUBS sky130_fd_sc_hd__dfxtp_1_92/a_592_47# VSUBS VSUBS sky130_fd_sc_hd__dfxtp_1_92/a_561_413#
+ VSUBS VSUBS VSUBS sky130_fd_sc_hd__dfxtp_1
Xsky130_fd_sc_hd__conb_1_6 VSUBS VSUBS VSUBS VSUBS VSUBS VSUBS sky130_fd_sc_hd__conb_1_7/a_21_232#
+ sky130_fd_sc_hd__conb_1_7/a_159_232# sky130_fd_sc_hd__conb_1
Xsky130_fd_sc_hd__mux2i_1_3 VSUBS VSUBS VSUBS VSUBS VSUBS VSUBS VSUBS VSUBS VSUBS
+ VSUBS VSUBS VSUBS sky130_fd_sc_hd__mux2i_1
Xsky130_fd_sc_hd__a31oi_1_3 VSUBS VSUBS VSUBS VSUBS VSUBS VSUBS VSUBS VSUBS VSUBS
+ sky130_fd_sc_hd__a31oi_1_3/a_181_47# VSUBS sky130_fd_sc_hd__a31oi_1
Xsky130_fd_sc_hd__decap_12_808 VSUBS VSUBS VSUBS VSUBS sky130_fd_sc_hd__decap_12
Xsky130_fd_sc_hd__decap_12_819 VSUBS VSUBS VSUBS VSUBS sky130_fd_sc_hd__decap_12
Xsky130_fd_sc_hd__decap_3_20 VSUBS VSUBS VSUBS VSUBS sky130_fd_sc_hd__decap_3
Xsky130_fd_sc_hd__decap_3_64 VSUBS VSUBS VSUBS VSUBS sky130_fd_sc_hd__decap_3
Xsky130_fd_sc_hd__decap_3_75 VSUBS VSUBS VSUBS VSUBS sky130_fd_sc_hd__decap_3
Xsky130_fd_sc_hd__decap_3_31 VSUBS VSUBS VSUBS VSUBS sky130_fd_sc_hd__decap_3
Xsky130_fd_sc_hd__decap_3_42 VSUBS VSUBS VSUBS VSUBS sky130_fd_sc_hd__decap_3
Xsky130_fd_sc_hd__decap_3_53 VSUBS VSUBS VSUBS VSUBS sky130_fd_sc_hd__decap_3
Xsky130_fd_sc_hd__decap_3_86 VSUBS VSUBS VSUBS VSUBS sky130_fd_sc_hd__decap_3
Xsky130_fd_sc_hd__decap_3_97 VSUBS VSUBS VSUBS VSUBS sky130_fd_sc_hd__decap_3
Xsky130_fd_sc_hd__edfxtp_1_2 VSUBS VSUBS VSUBS VSUBS sky130_fd_sc_hd__edfxtp_1_2/CLK
+ VSUBS VSUBS VSUBS sky130_fd_sc_hd__edfxtp_1_2/a_1717_47# sky130_fd_sc_hd__edfxtp_1_2/a_1514_47#
+ VSUBS sky130_fd_sc_hd__edfxtp_1_2/a_1500_413# sky130_fd_sc_hd__edfxtp_1_2/a_729_47#
+ VSUBS VSUBS VSUBS VSUBS sky130_fd_sc_hd__edfxtp_1_2/a_729_369# VSUBS sky130_fd_sc_hd__edfxtp_1_2/a_1675_413#
+ VSUBS VSUBS sky130_fd_sc_hd__edfxtp_1
Xsky130_fd_sc_hd__decap_12_649 VSUBS VSUBS VSUBS VSUBS sky130_fd_sc_hd__decap_12
Xsky130_fd_sc_hd__decap_12_605 VSUBS VSUBS VSUBS VSUBS sky130_fd_sc_hd__decap_12
Xsky130_fd_sc_hd__decap_12_616 VSUBS VSUBS VSUBS VSUBS sky130_fd_sc_hd__decap_12
Xsky130_fd_sc_hd__decap_12_627 VSUBS VSUBS VSUBS VSUBS sky130_fd_sc_hd__decap_12
Xsky130_fd_sc_hd__decap_12_638 VSUBS VSUBS VSUBS VSUBS sky130_fd_sc_hd__decap_12
Xsky130_fd_sc_hd__o21ai_0_32 VSUBS VSUBS VSUBS VSUBS VSUBS VSUBS VSUBS VSUBS VSUBS
+ sky130_fd_sc_hd__o21ai_0
Xsky130_fd_sc_hd__o21ai_0_10 VSUBS VSUBS VSUBS VSUBS VSUBS VSUBS VSUBS VSUBS VSUBS
+ sky130_fd_sc_hd__o21ai_0
Xsky130_fd_sc_hd__o21ai_0_21 VSUBS VSUBS VSUBS VSUBS VSUBS VSUBS VSUBS VSUBS VSUBS
+ sky130_fd_sc_hd__o21ai_0
Xsky130_fd_sc_hd__o21ai_0_54 VSUBS VSUBS VSUBS VSUBS VSUBS VSUBS VSUBS VSUBS VSUBS
+ sky130_fd_sc_hd__o21ai_0
Xsky130_fd_sc_hd__o21ai_0_65 VSUBS VSUBS VSUBS VSUBS VSUBS VSUBS VSUBS VSUBS VSUBS
+ sky130_fd_sc_hd__o21ai_0
Xsky130_fd_sc_hd__o21ai_0_43 VSUBS VSUBS VSUBS VSUBS VSUBS VSUBS VSUBS VSUBS VSUBS
+ sky130_fd_sc_hd__o21ai_0
Xsky130_fd_sc_hd__nand2_1_4 VSUBS VSUBS VSUBS VSUBS VSUBS VSUBS VSUBS sky130_fd_sc_hd__nand2_1
Xsky130_fd_sc_hd__a21oi_1_42 VSUBS VSUBS VSUBS VSUBS VSUBS VSUBS VSUBS VSUBS VSUBS
+ sky130_fd_sc_hd__a21oi_1
Xsky130_fd_sc_hd__a21oi_1_31 VSUBS VSUBS VSUBS VSUBS VSUBS VSUBS VSUBS VSUBS VSUBS
+ sky130_fd_sc_hd__a21oi_1
Xsky130_fd_sc_hd__a21oi_1_53 VSUBS VSUBS VSUBS VSUBS VSUBS VSUBS VSUBS VSUBS VSUBS
+ sky130_fd_sc_hd__a21oi_1
Xsky130_fd_sc_hd__a21oi_1_20 VSUBS VSUBS VSUBS VSUBS VSUBS VSUBS VSUBS VSUBS VSUBS
+ sky130_fd_sc_hd__a21oi_1
Xsky130_fd_sc_hd__decap_6_113 VSUBS VSUBS VSUBS VSUBS sky130_fd_sc_hd__decap_6
Xsky130_fd_sc_hd__decap_6_102 VSUBS VSUBS VSUBS VSUBS sky130_fd_sc_hd__decap_6
Xsky130_fd_sc_hd__nor3_1_1 VSUBS VSUBS VSUBS VSUBS sky130_fd_sc_hd__nor3_1_1/C VSUBS
+ VSUBS VSUBS sky130_fd_sc_hd__nor3_1
Xsky130_fd_sc_hd__decap_12_71 VSUBS VSUBS VSUBS VSUBS sky130_fd_sc_hd__decap_12
Xsky130_fd_sc_hd__decap_12_60 VSUBS VSUBS VSUBS VSUBS sky130_fd_sc_hd__decap_12
Xsky130_fd_sc_hd__decap_12_93 VSUBS VSUBS VSUBS VSUBS sky130_fd_sc_hd__decap_12
Xsky130_fd_sc_hd__decap_12_82 VSUBS VSUBS VSUBS VSUBS sky130_fd_sc_hd__decap_12
Xsky130_fd_sc_hd__decap_12_413 VSUBS VSUBS VSUBS VSUBS sky130_fd_sc_hd__decap_12
Xsky130_fd_sc_hd__decap_12_402 VSUBS VSUBS VSUBS VSUBS sky130_fd_sc_hd__decap_12
Xsky130_fd_sc_hd__decap_12_479 VSUBS VSUBS VSUBS VSUBS sky130_fd_sc_hd__decap_12
Xsky130_fd_sc_hd__decap_12_468 VSUBS VSUBS VSUBS VSUBS sky130_fd_sc_hd__decap_12
Xsky130_fd_sc_hd__o221ai_1_0 VSUBS VSUBS VSUBS VSUBS VSUBS VSUBS VSUBS VSUBS VSUBS
+ VSUBS VSUBS VSUBS sky130_fd_sc_hd__o221ai_1
Xsky130_fd_sc_hd__decap_12_457 VSUBS VSUBS VSUBS VSUBS sky130_fd_sc_hd__decap_12
Xsky130_fd_sc_hd__decap_12_435 VSUBS VSUBS VSUBS VSUBS sky130_fd_sc_hd__decap_12
Xsky130_fd_sc_hd__decap_12_424 VSUBS VSUBS VSUBS VSUBS sky130_fd_sc_hd__decap_12
Xsky130_fd_sc_hd__decap_12_446 VSUBS VSUBS VSUBS VSUBS sky130_fd_sc_hd__decap_12
Xsky130_fd_sc_hd__decap_3_149 VSUBS VSUBS VSUBS VSUBS sky130_fd_sc_hd__decap_3
Xsky130_fd_sc_hd__decap_12_991 VSUBS VSUBS VSUBS VSUBS sky130_fd_sc_hd__decap_12
Xsky130_fd_sc_hd__decap_12_980 VSUBS VSUBS VSUBS VSUBS sky130_fd_sc_hd__decap_12
Xsky130_fd_sc_hd__decap_3_138 VSUBS VSUBS VSUBS VSUBS sky130_fd_sc_hd__decap_3
Xsky130_fd_sc_hd__decap_3_116 VSUBS VSUBS VSUBS VSUBS sky130_fd_sc_hd__decap_3
Xsky130_fd_sc_hd__decap_3_127 VSUBS VSUBS VSUBS VSUBS sky130_fd_sc_hd__decap_3
Xsky130_fd_sc_hd__decap_3_105 VSUBS VSUBS VSUBS VSUBS sky130_fd_sc_hd__decap_3
Xsky130_fd_sc_hd__decap_12_221 VSUBS VSUBS VSUBS VSUBS sky130_fd_sc_hd__decap_12
Xsky130_fd_sc_hd__decap_12_232 VSUBS VSUBS VSUBS VSUBS sky130_fd_sc_hd__decap_12
Xsky130_fd_sc_hd__decap_12_210 VSUBS VSUBS VSUBS VSUBS sky130_fd_sc_hd__decap_12
Xsky130_fd_sc_hd__decap_12_243 VSUBS VSUBS VSUBS VSUBS sky130_fd_sc_hd__decap_12
Xsky130_fd_sc_hd__decap_12_287 VSUBS VSUBS VSUBS VSUBS sky130_fd_sc_hd__decap_12
Xsky130_fd_sc_hd__decap_12_265 VSUBS VSUBS VSUBS VSUBS sky130_fd_sc_hd__decap_12
Xsky130_fd_sc_hd__decap_12_298 VSUBS VSUBS VSUBS VSUBS sky130_fd_sc_hd__decap_12
Xsky130_fd_sc_hd__decap_12_276 VSUBS VSUBS VSUBS VSUBS sky130_fd_sc_hd__decap_12
Xsky130_fd_sc_hd__decap_12_254 VSUBS VSUBS VSUBS VSUBS sky130_fd_sc_hd__decap_12
Xsky130_fd_sc_hd__xor2_1_13 VSUBS VSUBS VSUBS VSUBS VSUBS VSUBS VSUBS VSUBS VSUBS
+ sky130_fd_sc_hd__xor2_1
Xsky130_fd_sc_hd__and3_1_0 VSUBS VSUBS VSUBS VSUBS VSUBS VSUBS VSUBS VSUBS VSUBS sky130_fd_sc_hd__and3_1
Xsky130_fd_sc_hd__decap_8_208 VSUBS VSUBS VSUBS VSUBS sky130_fd_sc_hd__decap_8
Xsky130_fd_sc_hd__decap_8_219 VSUBS VSUBS VSUBS VSUBS sky130_fd_sc_hd__decap_8
Xsky130_fd_sc_hd__decap_6_75 VSUBS VSUBS VSUBS VSUBS sky130_fd_sc_hd__decap_6
Xsky130_fd_sc_hd__decap_6_64 VSUBS VSUBS VSUBS VSUBS sky130_fd_sc_hd__decap_6
Xsky130_fd_sc_hd__decap_6_31 VSUBS VSUBS VSUBS VSUBS sky130_fd_sc_hd__decap_6
Xsky130_fd_sc_hd__decap_6_42 VSUBS VSUBS VSUBS VSUBS sky130_fd_sc_hd__decap_6
Xsky130_fd_sc_hd__decap_6_20 VSUBS VSUBS VSUBS VSUBS sky130_fd_sc_hd__decap_6
Xsky130_fd_sc_hd__decap_6_53 VSUBS VSUBS VSUBS VSUBS sky130_fd_sc_hd__decap_6
Xsky130_fd_sc_hd__decap_6_97 VSUBS VSUBS VSUBS VSUBS sky130_fd_sc_hd__decap_6
Xsky130_fd_sc_hd__decap_6_86 VSUBS VSUBS VSUBS VSUBS sky130_fd_sc_hd__decap_6
Xsky130_fd_sc_hd__o21ai_0_0 VSUBS VSUBS VSUBS VSUBS sky130_fd_sc_hd__o21ai_0_0/B1
+ VSUBS VSUBS VSUBS VSUBS sky130_fd_sc_hd__o21ai_0
Xsky130_fd_sc_hd__clkinv_1_3 VSUBS VSUBS VSUBS VSUBS VSUBS VSUBS sky130_fd_sc_hd__clkinv_1
Xsky130_fd_sc_hd__decap_12_1061 VSUBS VSUBS VSUBS VSUBS sky130_fd_sc_hd__decap_12
Xsky130_fd_sc_hd__decap_12_1083 VSUBS VSUBS VSUBS VSUBS sky130_fd_sc_hd__decap_12
Xsky130_fd_sc_hd__decap_12_1050 VSUBS VSUBS VSUBS VSUBS sky130_fd_sc_hd__decap_12
Xsky130_fd_sc_hd__decap_12_1072 VSUBS VSUBS VSUBS VSUBS sky130_fd_sc_hd__decap_12
Xsky130_fd_sc_hd__decap_12_1094 VSUBS VSUBS VSUBS VSUBS sky130_fd_sc_hd__decap_12
Xsky130_fd_sc_hd__decap_4_7 VSUBS VSUBS VSUBS VSUBS sky130_fd_sc_hd__decap_4
Xsky130_fd_sc_hd__dfxtp_1_82 VSUBS VSUBS VSUBS VSUBS VSUBS VSUBS VSUBS sky130_fd_sc_hd__dfxtp_1_82/a_975_413#
+ VSUBS VSUBS sky130_fd_sc_hd__dfxtp_1_82/a_592_47# VSUBS VSUBS sky130_fd_sc_hd__dfxtp_1_82/a_561_413#
+ VSUBS VSUBS VSUBS sky130_fd_sc_hd__dfxtp_1
Xsky130_fd_sc_hd__dfxtp_1_71 VSUBS VSUBS VSUBS VSUBS VSUBS VSUBS VSUBS sky130_fd_sc_hd__dfxtp_1_71/a_975_413#
+ VSUBS VSUBS sky130_fd_sc_hd__dfxtp_1_71/a_592_47# VSUBS VSUBS sky130_fd_sc_hd__dfxtp_1_71/a_561_413#
+ VSUBS VSUBS VSUBS sky130_fd_sc_hd__dfxtp_1
Xsky130_fd_sc_hd__dfxtp_1_60 VSUBS VSUBS VSUBS VSUBS sky130_fd_sc_hd__dfxtp_1_60/CLK
+ VSUBS VSUBS sky130_fd_sc_hd__dfxtp_1_60/a_975_413# VSUBS VSUBS sky130_fd_sc_hd__dfxtp_1_60/a_592_47#
+ VSUBS VSUBS sky130_fd_sc_hd__dfxtp_1_60/a_561_413# VSUBS VSUBS VSUBS sky130_fd_sc_hd__dfxtp_1
Xsky130_fd_sc_hd__dfxtp_1_93 VSUBS VSUBS VSUBS VSUBS VSUBS VSUBS VSUBS sky130_fd_sc_hd__dfxtp_1_93/a_975_413#
+ VSUBS VSUBS sky130_fd_sc_hd__dfxtp_1_93/a_592_47# VSUBS VSUBS sky130_fd_sc_hd__dfxtp_1_93/a_561_413#
+ VSUBS VSUBS VSUBS sky130_fd_sc_hd__dfxtp_1
Xsky130_fd_sc_hd__conb_1_7 VSUBS VSUBS VSUBS VSUBS VSUBS VSUBS sky130_fd_sc_hd__conb_1_7/a_21_232#
+ sky130_fd_sc_hd__conb_1_7/a_159_232# sky130_fd_sc_hd__conb_1
Xsky130_fd_sc_hd__mux2i_1_4 VSUBS VSUBS VSUBS VSUBS VSUBS VSUBS VSUBS VSUBS VSUBS
+ VSUBS VSUBS VSUBS sky130_fd_sc_hd__mux2i_1
Xsky130_fd_sc_hd__a31oi_1_4 VSUBS VSUBS VSUBS VSUBS VSUBS VSUBS VSUBS VSUBS VSUBS
+ sky130_fd_sc_hd__a31oi_1_4/a_181_47# VSUBS sky130_fd_sc_hd__a31oi_1
Xsky130_fd_sc_hd__decap_12_809 VSUBS VSUBS VSUBS VSUBS sky130_fd_sc_hd__decap_12
Xsky130_fd_sc_hd__decap_3_54 VSUBS VSUBS VSUBS VSUBS sky130_fd_sc_hd__decap_3
Xsky130_fd_sc_hd__decap_3_21 VSUBS VSUBS VSUBS VSUBS sky130_fd_sc_hd__decap_3
Xsky130_fd_sc_hd__decap_3_76 VSUBS VSUBS VSUBS VSUBS sky130_fd_sc_hd__decap_3
Xsky130_fd_sc_hd__decap_3_65 VSUBS VSUBS VSUBS VSUBS sky130_fd_sc_hd__decap_3
Xsky130_fd_sc_hd__decap_3_10 VSUBS VSUBS VSUBS VSUBS sky130_fd_sc_hd__decap_3
Xsky130_fd_sc_hd__decap_3_43 VSUBS VSUBS VSUBS VSUBS sky130_fd_sc_hd__decap_3
Xsky130_fd_sc_hd__decap_3_32 VSUBS VSUBS VSUBS VSUBS sky130_fd_sc_hd__decap_3
Xsky130_fd_sc_hd__decap_3_87 VSUBS VSUBS VSUBS VSUBS sky130_fd_sc_hd__decap_3
Xsky130_fd_sc_hd__decap_3_98 VSUBS VSUBS VSUBS VSUBS sky130_fd_sc_hd__decap_3
Xsky130_fd_sc_hd__dfxtp_1_0 VSUBS VSUBS VSUBS VSUBS VSUBS VSUBS VSUBS sky130_fd_sc_hd__dfxtp_1_0/a_975_413#
+ VSUBS VSUBS sky130_fd_sc_hd__dfxtp_1_0/a_592_47# VSUBS VSUBS sky130_fd_sc_hd__dfxtp_1_0/a_561_413#
+ VSUBS VSUBS VSUBS sky130_fd_sc_hd__dfxtp_1
Xsky130_fd_sc_hd__edfxtp_1_3 VSUBS VSUBS VSUBS VSUBS VSUBS VSUBS VSUBS VSUBS VSUBS
+ sky130_fd_sc_hd__edfxtp_1_3/a_1514_47# VSUBS sky130_fd_sc_hd__edfxtp_1_3/a_1500_413#
+ sky130_fd_sc_hd__edfxtp_1_3/a_729_47# VSUBS VSUBS VSUBS VSUBS sky130_fd_sc_hd__edfxtp_1_3/a_729_369#
+ VSUBS sky130_fd_sc_hd__edfxtp_1_3/a_1675_413# VSUBS VSUBS sky130_fd_sc_hd__edfxtp_1
Xsky130_fd_sc_hd__decap_12_617 VSUBS VSUBS VSUBS VSUBS sky130_fd_sc_hd__decap_12
Xsky130_fd_sc_hd__decap_12_628 VSUBS VSUBS VSUBS VSUBS sky130_fd_sc_hd__decap_12
Xsky130_fd_sc_hd__decap_12_606 VSUBS VSUBS VSUBS VSUBS sky130_fd_sc_hd__decap_12
Xsky130_fd_sc_hd__decap_12_639 VSUBS VSUBS VSUBS VSUBS sky130_fd_sc_hd__decap_12
Xsky130_fd_sc_hd__o21ai_0_55 VSUBS VSUBS VSUBS VSUBS VSUBS VSUBS VSUBS VSUBS VSUBS
+ sky130_fd_sc_hd__o21ai_0
Xsky130_fd_sc_hd__o21ai_0_44 VSUBS VSUBS VSUBS VSUBS VSUBS VSUBS VSUBS VSUBS VSUBS
+ sky130_fd_sc_hd__o21ai_0
Xsky130_fd_sc_hd__o21ai_0_66 VSUBS VSUBS VSUBS VSUBS VSUBS VSUBS VSUBS VSUBS VSUBS
+ sky130_fd_sc_hd__o21ai_0
Xsky130_fd_sc_hd__o21ai_0_33 VSUBS VSUBS VSUBS VSUBS VSUBS VSUBS VSUBS VSUBS VSUBS
+ sky130_fd_sc_hd__o21ai_0
Xsky130_fd_sc_hd__o21ai_0_11 VSUBS VSUBS VSUBS VSUBS VSUBS VSUBS VSUBS VSUBS VSUBS
+ sky130_fd_sc_hd__o21ai_0
Xsky130_fd_sc_hd__o21ai_0_22 VSUBS VSUBS VSUBS VSUBS sky130_fd_sc_hd__o21ai_0_22/B1
+ VSUBS VSUBS VSUBS VSUBS sky130_fd_sc_hd__o21ai_0
Xsky130_fd_sc_hd__nand2_1_5 VSUBS VSUBS VSUBS VSUBS VSUBS VSUBS VSUBS sky130_fd_sc_hd__nand2_1
Xsky130_fd_sc_hd__a21oi_1_32 VSUBS VSUBS VSUBS VSUBS VSUBS VSUBS VSUBS VSUBS VSUBS
+ sky130_fd_sc_hd__a21oi_1
Xsky130_fd_sc_hd__a21oi_1_43 VSUBS VSUBS VSUBS VSUBS VSUBS VSUBS VSUBS VSUBS VSUBS
+ sky130_fd_sc_hd__a21oi_1
Xsky130_fd_sc_hd__a21oi_1_21 VSUBS VSUBS VSUBS VSUBS VSUBS VSUBS VSUBS VSUBS VSUBS
+ sky130_fd_sc_hd__a21oi_1
Xsky130_fd_sc_hd__a21oi_1_10 VSUBS VSUBS VSUBS VSUBS sky130_fd_sc_hd__a21oi_1_10/A2
+ VSUBS VSUBS VSUBS VSUBS sky130_fd_sc_hd__a21oi_1
Xsky130_fd_sc_hd__decap_6_114 VSUBS VSUBS VSUBS VSUBS sky130_fd_sc_hd__decap_6
Xsky130_fd_sc_hd__decap_6_103 VSUBS VSUBS VSUBS VSUBS sky130_fd_sc_hd__decap_6
Xsky130_fd_sc_hd__decap_12_50 VSUBS VSUBS VSUBS VSUBS sky130_fd_sc_hd__decap_12
Xsky130_fd_sc_hd__inv_1_0 VSUBS VSUBS VSUBS VSUBS VSUBS VSUBS sky130_fd_sc_hd__inv_1
Xsky130_fd_sc_hd__decap_12_61 VSUBS VSUBS VSUBS VSUBS sky130_fd_sc_hd__decap_12
Xsky130_fd_sc_hd__nor3_1_2 VSUBS VSUBS VSUBS VSUBS VSUBS VSUBS VSUBS VSUBS sky130_fd_sc_hd__nor3_1
Xsky130_fd_sc_hd__decap_12_72 VSUBS VSUBS VSUBS VSUBS sky130_fd_sc_hd__decap_12
Xsky130_fd_sc_hd__decap_12_94 VSUBS VSUBS VSUBS VSUBS sky130_fd_sc_hd__decap_12
Xsky130_fd_sc_hd__decap_12_83 VSUBS VSUBS VSUBS VSUBS sky130_fd_sc_hd__decap_12
Xsky130_fd_sc_hd__decap_12_414 VSUBS VSUBS VSUBS VSUBS sky130_fd_sc_hd__decap_12
Xsky130_fd_sc_hd__decap_12_403 VSUBS VSUBS VSUBS VSUBS sky130_fd_sc_hd__decap_12
Xsky130_fd_sc_hd__decap_12_425 VSUBS VSUBS VSUBS VSUBS sky130_fd_sc_hd__decap_12
Xsky130_fd_sc_hd__o221ai_1_1 VSUBS VSUBS VSUBS VSUBS VSUBS VSUBS VSUBS VSUBS VSUBS
+ VSUBS VSUBS VSUBS sky130_fd_sc_hd__o221ai_1
Xsky130_fd_sc_hd__decap_12_458 VSUBS VSUBS VSUBS VSUBS sky130_fd_sc_hd__decap_12
Xsky130_fd_sc_hd__decap_12_436 VSUBS VSUBS VSUBS VSUBS sky130_fd_sc_hd__decap_12
Xsky130_fd_sc_hd__decap_12_447 VSUBS VSUBS VSUBS VSUBS sky130_fd_sc_hd__decap_12
Xsky130_fd_sc_hd__decap_12_469 VSUBS VSUBS VSUBS VSUBS sky130_fd_sc_hd__decap_12
Xsky130_fd_sc_hd__decap_12_981 VSUBS VSUBS VSUBS VSUBS sky130_fd_sc_hd__decap_12
Xsky130_fd_sc_hd__decap_12_970 VSUBS VSUBS VSUBS VSUBS sky130_fd_sc_hd__decap_12
Xsky130_fd_sc_hd__decap_12_992 VSUBS VSUBS VSUBS VSUBS sky130_fd_sc_hd__decap_12
Xsky130_fd_sc_hd__decap_3_139 VSUBS VSUBS VSUBS VSUBS sky130_fd_sc_hd__decap_3
Xsky130_fd_sc_hd__decap_3_117 VSUBS VSUBS VSUBS VSUBS sky130_fd_sc_hd__decap_3
Xsky130_fd_sc_hd__decap_3_128 VSUBS VSUBS VSUBS VSUBS sky130_fd_sc_hd__decap_3
Xsky130_fd_sc_hd__decap_3_106 VSUBS VSUBS VSUBS VSUBS sky130_fd_sc_hd__decap_3
Xsky130_fd_sc_hd__decap_12_222 VSUBS VSUBS VSUBS VSUBS sky130_fd_sc_hd__decap_12
Xsky130_fd_sc_hd__decap_12_233 VSUBS VSUBS VSUBS VSUBS sky130_fd_sc_hd__decap_12
Xsky130_fd_sc_hd__decap_12_211 VSUBS VSUBS VSUBS VSUBS sky130_fd_sc_hd__decap_12
Xsky130_fd_sc_hd__decap_12_200 VSUBS VSUBS VSUBS VSUBS sky130_fd_sc_hd__decap_12
Xsky130_fd_sc_hd__decap_12_266 VSUBS VSUBS VSUBS VSUBS sky130_fd_sc_hd__decap_12
Xsky130_fd_sc_hd__decap_12_255 VSUBS VSUBS VSUBS VSUBS sky130_fd_sc_hd__decap_12
Xsky130_fd_sc_hd__decap_12_244 VSUBS VSUBS VSUBS VSUBS sky130_fd_sc_hd__decap_12
Xsky130_fd_sc_hd__decap_12_299 VSUBS VSUBS VSUBS VSUBS sky130_fd_sc_hd__decap_12
Xsky130_fd_sc_hd__decap_12_277 VSUBS VSUBS VSUBS VSUBS sky130_fd_sc_hd__decap_12
Xsky130_fd_sc_hd__decap_12_288 VSUBS VSUBS VSUBS VSUBS sky130_fd_sc_hd__decap_12
Xsky130_fd_sc_hd__mux2_1_0 VSUBS VSUBS VSUBS VSUBS VSUBS VSUBS VSUBS VSUBS VSUBS VSUBS
+ sky130_fd_sc_hd__mux2_1
Xsky130_fd_sc_hd__xor2_1_14 VSUBS VSUBS VSUBS VSUBS VSUBS VSUBS VSUBS VSUBS VSUBS
+ sky130_fd_sc_hd__xor2_1
Xsky130_fd_sc_hd__and3_1_1 VSUBS VSUBS VSUBS VSUBS VSUBS VSUBS VSUBS VSUBS VSUBS sky130_fd_sc_hd__and3_1
Xsky130_fd_sc_hd__decap_8_209 VSUBS VSUBS VSUBS VSUBS sky130_fd_sc_hd__decap_8
Xsky130_fd_sc_hd__decap_6_76 VSUBS VSUBS VSUBS VSUBS sky130_fd_sc_hd__decap_6
Xsky130_fd_sc_hd__decap_6_65 VSUBS VSUBS VSUBS VSUBS sky130_fd_sc_hd__decap_6
Xsky130_fd_sc_hd__decap_6_87 VSUBS VSUBS VSUBS VSUBS sky130_fd_sc_hd__decap_6
Xsky130_fd_sc_hd__decap_6_98 VSUBS VSUBS VSUBS VSUBS sky130_fd_sc_hd__decap_6
Xsky130_fd_sc_hd__decap_6_10 VSUBS VSUBS VSUBS VSUBS sky130_fd_sc_hd__decap_6
Xsky130_fd_sc_hd__decap_6_32 VSUBS VSUBS VSUBS VSUBS sky130_fd_sc_hd__decap_6
Xsky130_fd_sc_hd__decap_6_43 VSUBS VSUBS VSUBS VSUBS sky130_fd_sc_hd__decap_6
Xsky130_fd_sc_hd__decap_6_54 VSUBS VSUBS VSUBS VSUBS sky130_fd_sc_hd__decap_6
Xsky130_fd_sc_hd__decap_6_21 VSUBS VSUBS VSUBS VSUBS sky130_fd_sc_hd__decap_6
Xsky130_fd_sc_hd__o21ai_0_1 VSUBS VSUBS VSUBS VSUBS VSUBS VSUBS VSUBS VSUBS VSUBS
+ sky130_fd_sc_hd__o21ai_0
Xsky130_fd_sc_hd__clkinv_1_4 VSUBS VSUBS VSUBS VSUBS VSUBS VSUBS sky130_fd_sc_hd__clkinv_1
Xsky130_fd_sc_hd__decap_12_1051 VSUBS VSUBS VSUBS VSUBS sky130_fd_sc_hd__decap_12
Xsky130_fd_sc_hd__decap_12_1062 VSUBS VSUBS VSUBS VSUBS sky130_fd_sc_hd__decap_12
Xsky130_fd_sc_hd__decap_12_1040 VSUBS VSUBS VSUBS VSUBS sky130_fd_sc_hd__decap_12
Xsky130_fd_sc_hd__decap_12_1073 VSUBS VSUBS VSUBS VSUBS sky130_fd_sc_hd__decap_12
Xsky130_fd_sc_hd__decap_12_1084 VSUBS VSUBS VSUBS VSUBS sky130_fd_sc_hd__decap_12
Xsky130_fd_sc_hd__decap_12_1095 VSUBS VSUBS VSUBS VSUBS sky130_fd_sc_hd__decap_12
Xsky130_fd_sc_hd__decap_4_8 VSUBS VSUBS VSUBS VSUBS sky130_fd_sc_hd__decap_4
Xsky130_fd_sc_hd__dfxtp_1_83 VSUBS VSUBS VSUBS VSUBS sky130_fd_sc_hd__edfxtp_1_2/CLK
+ VSUBS VSUBS sky130_fd_sc_hd__dfxtp_1_83/a_975_413# VSUBS VSUBS sky130_fd_sc_hd__dfxtp_1_83/a_592_47#
+ VSUBS VSUBS sky130_fd_sc_hd__dfxtp_1_83/a_561_413# VSUBS VSUBS VSUBS sky130_fd_sc_hd__dfxtp_1
Xsky130_fd_sc_hd__dfxtp_1_72 VSUBS VSUBS VSUBS VSUBS VSUBS VSUBS VSUBS sky130_fd_sc_hd__dfxtp_1_72/a_975_413#
+ VSUBS VSUBS sky130_fd_sc_hd__dfxtp_1_72/a_592_47# VSUBS VSUBS sky130_fd_sc_hd__dfxtp_1_72/a_561_413#
+ VSUBS VSUBS VSUBS sky130_fd_sc_hd__dfxtp_1
Xsky130_fd_sc_hd__dfxtp_1_50 VSUBS VSUBS VSUBS VSUBS VSUBS VSUBS VSUBS sky130_fd_sc_hd__dfxtp_1_50/a_975_413#
+ VSUBS VSUBS sky130_fd_sc_hd__dfxtp_1_50/a_592_47# VSUBS VSUBS sky130_fd_sc_hd__dfxtp_1_50/a_561_413#
+ VSUBS VSUBS VSUBS sky130_fd_sc_hd__dfxtp_1
Xsky130_fd_sc_hd__dfxtp_1_61 VSUBS VSUBS VSUBS VSUBS VSUBS VSUBS VSUBS sky130_fd_sc_hd__dfxtp_1_61/a_975_413#
+ VSUBS VSUBS sky130_fd_sc_hd__dfxtp_1_61/a_592_47# VSUBS VSUBS sky130_fd_sc_hd__dfxtp_1_61/a_561_413#
+ VSUBS VSUBS VSUBS sky130_fd_sc_hd__dfxtp_1
Xsky130_fd_sc_hd__dfxtp_1_94 VSUBS VSUBS VSUBS VSUBS sky130_fd_sc_hd__dfxtp_1_94/CLK
+ VSUBS VSUBS sky130_fd_sc_hd__dfxtp_1_94/a_975_413# VSUBS VSUBS sky130_fd_sc_hd__dfxtp_1_94/a_592_47#
+ VSUBS VSUBS sky130_fd_sc_hd__dfxtp_1_94/a_561_413# VSUBS VSUBS VSUBS sky130_fd_sc_hd__dfxtp_1
Xsky130_fd_sc_hd__conb_1_8 VSUBS VSUBS VSUBS VSUBS VSUBS VSUBS sky130_fd_sc_hd__conb_1_8/a_21_232#
+ sky130_fd_sc_hd__conb_1_8/a_159_232# sky130_fd_sc_hd__conb_1
Xsky130_fd_sc_hd__mux2i_1_5 VSUBS VSUBS VSUBS VSUBS VSUBS VSUBS VSUBS VSUBS VSUBS
+ VSUBS VSUBS VSUBS sky130_fd_sc_hd__mux2i_1
Xsky130_fd_sc_hd__a31oi_1_5 VSUBS VSUBS VSUBS VSUBS VSUBS VSUBS VSUBS VSUBS VSUBS
+ sky130_fd_sc_hd__a31oi_1_5/a_181_47# VSUBS sky130_fd_sc_hd__a31oi_1
Xsky130_fd_sc_hd__decap_3_11 VSUBS VSUBS VSUBS VSUBS sky130_fd_sc_hd__decap_3
Xsky130_fd_sc_hd__decap_3_77 VSUBS VSUBS VSUBS VSUBS sky130_fd_sc_hd__decap_3
Xsky130_fd_sc_hd__decap_3_22 VSUBS VSUBS VSUBS VSUBS sky130_fd_sc_hd__decap_3
Xsky130_fd_sc_hd__decap_3_66 VSUBS VSUBS VSUBS VSUBS sky130_fd_sc_hd__decap_3
Xsky130_fd_sc_hd__decap_3_33 VSUBS VSUBS VSUBS VSUBS sky130_fd_sc_hd__decap_3
Xsky130_fd_sc_hd__decap_3_44 VSUBS VSUBS VSUBS VSUBS sky130_fd_sc_hd__decap_3
Xsky130_fd_sc_hd__decap_3_88 VSUBS VSUBS VSUBS VSUBS sky130_fd_sc_hd__decap_3
Xsky130_fd_sc_hd__decap_3_55 VSUBS VSUBS VSUBS VSUBS sky130_fd_sc_hd__decap_3
Xsky130_fd_sc_hd__decap_3_99 VSUBS VSUBS VSUBS VSUBS sky130_fd_sc_hd__decap_3
Xsky130_fd_sc_hd__dfxtp_1_1 VSUBS VSUBS VSUBS VSUBS VSUBS VSUBS VSUBS sky130_fd_sc_hd__dfxtp_1_1/a_975_413#
+ VSUBS VSUBS sky130_fd_sc_hd__dfxtp_1_1/a_592_47# VSUBS VSUBS sky130_fd_sc_hd__dfxtp_1_1/a_561_413#
+ VSUBS VSUBS VSUBS sky130_fd_sc_hd__dfxtp_1
Xsky130_fd_sc_hd__edfxtp_1_4 VSUBS VSUBS VSUBS VSUBS VSUBS VSUBS VSUBS VSUBS sky130_fd_sc_hd__edfxtp_1_4/a_1717_47#
+ sky130_fd_sc_hd__edfxtp_1_4/a_1514_47# VSUBS sky130_fd_sc_hd__edfxtp_1_4/a_1500_413#
+ sky130_fd_sc_hd__edfxtp_1_4/a_729_47# VSUBS VSUBS VSUBS VSUBS sky130_fd_sc_hd__edfxtp_1_4/a_729_369#
+ VSUBS sky130_fd_sc_hd__edfxtp_1_4/a_1675_413# VSUBS VSUBS sky130_fd_sc_hd__edfxtp_1
Xsky130_fd_sc_hd__decap_12_607 VSUBS VSUBS VSUBS VSUBS sky130_fd_sc_hd__decap_12
Xsky130_fd_sc_hd__decap_12_618 VSUBS VSUBS VSUBS VSUBS sky130_fd_sc_hd__decap_12
Xsky130_fd_sc_hd__decap_12_629 VSUBS VSUBS VSUBS VSUBS sky130_fd_sc_hd__decap_12
Xsky130_fd_sc_hd__o21ai_0_56 VSUBS VSUBS VSUBS VSUBS VSUBS VSUBS VSUBS VSUBS VSUBS
+ sky130_fd_sc_hd__o21ai_0
Xsky130_fd_sc_hd__o21ai_0_45 VSUBS VSUBS VSUBS VSUBS VSUBS VSUBS VSUBS VSUBS VSUBS
+ sky130_fd_sc_hd__o21ai_0
Xsky130_fd_sc_hd__o21ai_0_34 VSUBS VSUBS VSUBS VSUBS VSUBS VSUBS VSUBS VSUBS VSUBS
+ sky130_fd_sc_hd__o21ai_0
Xsky130_fd_sc_hd__nand2_1_6 VSUBS VSUBS VSUBS VSUBS VSUBS VSUBS VSUBS sky130_fd_sc_hd__nand2_1
Xsky130_fd_sc_hd__o21ai_0_23 VSUBS VSUBS VSUBS VSUBS VSUBS VSUBS VSUBS VSUBS VSUBS
+ sky130_fd_sc_hd__o21ai_0
Xsky130_fd_sc_hd__o21ai_0_12 VSUBS VSUBS VSUBS VSUBS VSUBS VSUBS VSUBS VSUBS VSUBS
+ sky130_fd_sc_hd__o21ai_0
Xsky130_fd_sc_hd__a21oi_1_44 VSUBS VSUBS VSUBS VSUBS VSUBS VSUBS VSUBS VSUBS VSUBS
+ sky130_fd_sc_hd__a21oi_1
Xsky130_fd_sc_hd__a21oi_1_33 VSUBS VSUBS VSUBS VSUBS VSUBS VSUBS VSUBS VSUBS VSUBS
+ sky130_fd_sc_hd__a21oi_1
Xsky130_fd_sc_hd__a21oi_1_11 VSUBS VSUBS VSUBS VSUBS VSUBS VSUBS VSUBS VSUBS VSUBS
+ sky130_fd_sc_hd__a21oi_1
Xsky130_fd_sc_hd__a21oi_1_22 VSUBS VSUBS VSUBS VSUBS VSUBS VSUBS VSUBS VSUBS VSUBS
+ sky130_fd_sc_hd__a21oi_1
Xsky130_fd_sc_hd__decap_6_115 VSUBS VSUBS VSUBS VSUBS sky130_fd_sc_hd__decap_6
Xsky130_fd_sc_hd__decap_6_104 VSUBS VSUBS VSUBS VSUBS sky130_fd_sc_hd__decap_6
Xsky130_fd_sc_hd__decap_12_40 VSUBS VSUBS VSUBS VSUBS sky130_fd_sc_hd__decap_12
Xsky130_fd_sc_hd__decap_12_73 VSUBS VSUBS VSUBS VSUBS sky130_fd_sc_hd__decap_12
Xsky130_fd_sc_hd__decap_12_51 VSUBS VSUBS VSUBS VSUBS sky130_fd_sc_hd__decap_12
Xsky130_fd_sc_hd__inv_1_1 VSUBS VSUBS VSUBS VSUBS VSUBS VSUBS sky130_fd_sc_hd__inv_1
Xsky130_fd_sc_hd__decap_12_62 VSUBS VSUBS VSUBS VSUBS sky130_fd_sc_hd__decap_12
Xsky130_fd_sc_hd__decap_12_84 VSUBS VSUBS VSUBS VSUBS sky130_fd_sc_hd__decap_12
Xsky130_fd_sc_hd__decap_12_95 VSUBS VSUBS VSUBS VSUBS sky130_fd_sc_hd__decap_12
Xsky130_fd_sc_hd__nor3_1_3 VSUBS VSUBS VSUBS VSUBS VSUBS VSUBS VSUBS VSUBS sky130_fd_sc_hd__nor3_1
Xsky130_fd_sc_hd__decap_12_404 VSUBS VSUBS VSUBS VSUBS sky130_fd_sc_hd__decap_12
Xsky130_fd_sc_hd__decap_12_448 VSUBS VSUBS VSUBS VSUBS sky130_fd_sc_hd__decap_12
Xsky130_fd_sc_hd__decap_12_459 VSUBS VSUBS VSUBS VSUBS sky130_fd_sc_hd__decap_12
Xsky130_fd_sc_hd__decap_12_415 VSUBS VSUBS VSUBS VSUBS sky130_fd_sc_hd__decap_12
Xsky130_fd_sc_hd__decap_12_437 VSUBS VSUBS VSUBS VSUBS sky130_fd_sc_hd__decap_12
Xsky130_fd_sc_hd__decap_12_426 VSUBS VSUBS VSUBS VSUBS sky130_fd_sc_hd__decap_12
Xsky130_fd_sc_hd__decap_12_993 VSUBS VSUBS VSUBS VSUBS sky130_fd_sc_hd__decap_12
Xsky130_fd_sc_hd__decap_12_982 VSUBS VSUBS VSUBS VSUBS sky130_fd_sc_hd__decap_12
Xsky130_fd_sc_hd__decap_12_960 VSUBS VSUBS VSUBS VSUBS sky130_fd_sc_hd__decap_12
Xsky130_fd_sc_hd__decap_12_971 VSUBS VSUBS VSUBS VSUBS sky130_fd_sc_hd__decap_12
Xsky130_fd_sc_hd__decap_3_107 VSUBS VSUBS VSUBS VSUBS sky130_fd_sc_hd__decap_3
Xsky130_fd_sc_hd__decap_3_118 VSUBS VSUBS VSUBS VSUBS sky130_fd_sc_hd__decap_3
Xsky130_fd_sc_hd__decap_3_129 VSUBS VSUBS VSUBS VSUBS sky130_fd_sc_hd__decap_3
Xsky130_fd_sc_hd__decap_12_212 VSUBS VSUBS VSUBS VSUBS sky130_fd_sc_hd__decap_12
Xsky130_fd_sc_hd__decap_12_234 VSUBS VSUBS VSUBS VSUBS sky130_fd_sc_hd__decap_12
Xsky130_fd_sc_hd__decap_12_289 VSUBS VSUBS VSUBS VSUBS sky130_fd_sc_hd__decap_12
Xsky130_fd_sc_hd__decap_12_223 VSUBS VSUBS VSUBS VSUBS sky130_fd_sc_hd__decap_12
Xsky130_fd_sc_hd__decap_12_267 VSUBS VSUBS VSUBS VSUBS sky130_fd_sc_hd__decap_12
Xsky130_fd_sc_hd__decap_12_278 VSUBS VSUBS VSUBS VSUBS sky130_fd_sc_hd__decap_12
Xsky130_fd_sc_hd__decap_12_256 VSUBS VSUBS VSUBS VSUBS sky130_fd_sc_hd__decap_12
Xsky130_fd_sc_hd__decap_12_245 VSUBS VSUBS VSUBS VSUBS sky130_fd_sc_hd__decap_12
Xsky130_fd_sc_hd__decap_12_201 VSUBS VSUBS VSUBS VSUBS sky130_fd_sc_hd__decap_12
Xsky130_fd_sc_hd__xor2_1_0 VSUBS VSUBS VSUBS VSUBS VSUBS VSUBS VSUBS VSUBS VSUBS sky130_fd_sc_hd__xor2_1
Xsky130_fd_sc_hd__mux2_1_1 VSUBS VSUBS VSUBS VSUBS VSUBS VSUBS VSUBS VSUBS VSUBS VSUBS
+ sky130_fd_sc_hd__mux2_1
Xsky130_fd_sc_hd__xor2_1_15 VSUBS VSUBS VSUBS VSUBS VSUBS VSUBS VSUBS VSUBS VSUBS
+ sky130_fd_sc_hd__xor2_1
Xsky130_fd_sc_hd__and3_1_2 VSUBS VSUBS VSUBS VSUBS VSUBS VSUBS VSUBS VSUBS VSUBS sky130_fd_sc_hd__and3_1
Xsky130_fd_sc_hd__decap_12_790 VSUBS VSUBS VSUBS VSUBS sky130_fd_sc_hd__decap_12
Xsky130_fd_sc_hd__decap_6_77 VSUBS VSUBS VSUBS VSUBS sky130_fd_sc_hd__decap_6
Xsky130_fd_sc_hd__decap_6_66 VSUBS VSUBS VSUBS VSUBS sky130_fd_sc_hd__decap_6
Xsky130_fd_sc_hd__decap_6_88 VSUBS VSUBS VSUBS VSUBS sky130_fd_sc_hd__decap_6
Xsky130_fd_sc_hd__decap_6_55 VSUBS VSUBS VSUBS VSUBS sky130_fd_sc_hd__decap_6
Xsky130_fd_sc_hd__decap_6_99 VSUBS VSUBS VSUBS VSUBS sky130_fd_sc_hd__decap_6
Xsky130_fd_sc_hd__decap_6_33 VSUBS VSUBS VSUBS VSUBS sky130_fd_sc_hd__decap_6
Xsky130_fd_sc_hd__decap_6_11 VSUBS VSUBS VSUBS VSUBS sky130_fd_sc_hd__decap_6
Xsky130_fd_sc_hd__decap_6_44 VSUBS VSUBS VSUBS VSUBS sky130_fd_sc_hd__decap_6
Xsky130_fd_sc_hd__decap_6_22 VSUBS VSUBS VSUBS VSUBS sky130_fd_sc_hd__decap_6
Xsky130_fd_sc_hd__o21ai_0_2 VSUBS VSUBS VSUBS VSUBS VSUBS VSUBS VSUBS VSUBS VSUBS
+ sky130_fd_sc_hd__o21ai_0
Xsky130_fd_sc_hd__clkinv_1_5 VSUBS VSUBS VSUBS VSUBS VSUBS VSUBS sky130_fd_sc_hd__clkinv_1
Xsky130_fd_sc_hd__decap_12_1063 VSUBS VSUBS VSUBS VSUBS sky130_fd_sc_hd__decap_12
Xsky130_fd_sc_hd__decap_12_1052 VSUBS VSUBS VSUBS VSUBS sky130_fd_sc_hd__decap_12
Xsky130_fd_sc_hd__decap_12_1096 VSUBS VSUBS VSUBS VSUBS sky130_fd_sc_hd__decap_12
Xsky130_fd_sc_hd__decap_12_1074 VSUBS VSUBS VSUBS VSUBS sky130_fd_sc_hd__decap_12
Xsky130_fd_sc_hd__decap_12_1085 VSUBS VSUBS VSUBS VSUBS sky130_fd_sc_hd__decap_12
Xsky130_fd_sc_hd__decap_12_1041 VSUBS VSUBS VSUBS VSUBS sky130_fd_sc_hd__decap_12
Xsky130_fd_sc_hd__decap_12_1030 VSUBS VSUBS VSUBS VSUBS sky130_fd_sc_hd__decap_12
Xsky130_fd_sc_hd__decap_4_9 VSUBS VSUBS VSUBS VSUBS sky130_fd_sc_hd__decap_4
Xsky130_fd_sc_hd__dfxtp_1_51 VSUBS VSUBS VSUBS VSUBS VSUBS VSUBS VSUBS sky130_fd_sc_hd__dfxtp_1_51/a_975_413#
+ VSUBS VSUBS sky130_fd_sc_hd__dfxtp_1_51/a_592_47# VSUBS VSUBS sky130_fd_sc_hd__dfxtp_1_51/a_561_413#
+ VSUBS VSUBS VSUBS sky130_fd_sc_hd__dfxtp_1
Xsky130_fd_sc_hd__dfxtp_1_40 VSUBS VSUBS VSUBS VSUBS VSUBS VSUBS VSUBS sky130_fd_sc_hd__dfxtp_1_40/a_975_413#
+ VSUBS VSUBS sky130_fd_sc_hd__dfxtp_1_40/a_592_47# VSUBS VSUBS sky130_fd_sc_hd__dfxtp_1_40/a_561_413#
+ VSUBS VSUBS VSUBS sky130_fd_sc_hd__dfxtp_1
Xsky130_fd_sc_hd__dfxtp_1_73 VSUBS VSUBS VSUBS VSUBS sky130_fd_sc_hd__dfxtp_1_73/CLK
+ VSUBS VSUBS sky130_fd_sc_hd__dfxtp_1_73/a_975_413# VSUBS VSUBS sky130_fd_sc_hd__dfxtp_1_73/a_592_47#
+ VSUBS VSUBS sky130_fd_sc_hd__dfxtp_1_73/a_561_413# VSUBS VSUBS VSUBS sky130_fd_sc_hd__dfxtp_1
Xsky130_fd_sc_hd__dfxtp_1_84 VSUBS VSUBS VSUBS VSUBS VSUBS VSUBS VSUBS sky130_fd_sc_hd__dfxtp_1_84/a_975_413#
+ VSUBS VSUBS sky130_fd_sc_hd__dfxtp_1_84/a_592_47# VSUBS VSUBS sky130_fd_sc_hd__dfxtp_1_84/a_561_413#
+ VSUBS VSUBS VSUBS sky130_fd_sc_hd__dfxtp_1
Xsky130_fd_sc_hd__dfxtp_1_62 VSUBS VSUBS VSUBS VSUBS VSUBS VSUBS VSUBS sky130_fd_sc_hd__dfxtp_1_62/a_975_413#
+ VSUBS VSUBS sky130_fd_sc_hd__dfxtp_1_62/a_592_47# VSUBS VSUBS sky130_fd_sc_hd__dfxtp_1_62/a_561_413#
+ VSUBS VSUBS VSUBS sky130_fd_sc_hd__dfxtp_1
Xsky130_fd_sc_hd__dfxtp_1_95 VSUBS VSUBS VSUBS VSUBS VSUBS VSUBS VSUBS sky130_fd_sc_hd__dfxtp_1_95/a_975_413#
+ VSUBS VSUBS sky130_fd_sc_hd__dfxtp_1_95/a_592_47# VSUBS VSUBS sky130_fd_sc_hd__dfxtp_1_95/a_561_413#
+ VSUBS VSUBS VSUBS sky130_fd_sc_hd__dfxtp_1
Xsky130_fd_sc_hd__conb_1_9 VSUBS VSUBS VSUBS VSUBS VSUBS VSUBS sky130_fd_sc_hd__conb_1_9/a_21_232#
+ sky130_fd_sc_hd__conb_1_9/a_159_232# sky130_fd_sc_hd__conb_1
Xsky130_fd_sc_hd__mux2i_1_6 VSUBS VSUBS VSUBS VSUBS VSUBS VSUBS VSUBS VSUBS VSUBS
+ VSUBS VSUBS VSUBS sky130_fd_sc_hd__mux2i_1
Xsky130_fd_sc_hd__decap_3_23 VSUBS VSUBS VSUBS VSUBS sky130_fd_sc_hd__decap_3
Xsky130_fd_sc_hd__decap_3_12 VSUBS VSUBS VSUBS VSUBS sky130_fd_sc_hd__decap_3
Xsky130_fd_sc_hd__decap_3_34 VSUBS VSUBS VSUBS VSUBS sky130_fd_sc_hd__decap_3
Xsky130_fd_sc_hd__decap_3_45 VSUBS VSUBS VSUBS VSUBS sky130_fd_sc_hd__decap_3
Xsky130_fd_sc_hd__decap_3_78 VSUBS VSUBS VSUBS VSUBS sky130_fd_sc_hd__decap_3
Xsky130_fd_sc_hd__decap_3_67 VSUBS VSUBS VSUBS VSUBS sky130_fd_sc_hd__decap_3
Xsky130_fd_sc_hd__decap_3_89 VSUBS VSUBS VSUBS VSUBS sky130_fd_sc_hd__decap_3
Xsky130_fd_sc_hd__decap_3_56 VSUBS VSUBS VSUBS VSUBS sky130_fd_sc_hd__decap_3
Xsky130_fd_sc_hd__dfxtp_1_2 VSUBS VSUBS VSUBS VSUBS VSUBS VSUBS VSUBS sky130_fd_sc_hd__dfxtp_1_2/a_975_413#
+ VSUBS VSUBS sky130_fd_sc_hd__dfxtp_1_2/a_592_47# VSUBS VSUBS sky130_fd_sc_hd__dfxtp_1_2/a_561_413#
+ VSUBS VSUBS VSUBS sky130_fd_sc_hd__dfxtp_1
Xsky130_fd_sc_hd__edfxtp_1_5 VSUBS VSUBS VSUBS VSUBS VSUBS VSUBS VSUBS VSUBS VSUBS
+ sky130_fd_sc_hd__edfxtp_1_5/a_1514_47# VSUBS sky130_fd_sc_hd__edfxtp_1_5/a_1500_413#
+ sky130_fd_sc_hd__edfxtp_1_5/a_729_47# VSUBS VSUBS VSUBS VSUBS sky130_fd_sc_hd__edfxtp_1_5/a_729_369#
+ VSUBS VSUBS VSUBS VSUBS sky130_fd_sc_hd__edfxtp_1
Xsky130_fd_sc_hd__decap_12_608 VSUBS VSUBS VSUBS VSUBS sky130_fd_sc_hd__decap_12
Xsky130_fd_sc_hd__decap_12_619 VSUBS VSUBS VSUBS VSUBS sky130_fd_sc_hd__decap_12
Xsky130_fd_sc_hd__o21ai_0_57 VSUBS VSUBS VSUBS VSUBS VSUBS VSUBS VSUBS VSUBS VSUBS
+ sky130_fd_sc_hd__o21ai_0
Xsky130_fd_sc_hd__o21ai_0_46 VSUBS VSUBS VSUBS VSUBS VSUBS VSUBS VSUBS VSUBS VSUBS
+ sky130_fd_sc_hd__o21ai_0
Xsky130_fd_sc_hd__o21ai_0_35 VSUBS VSUBS VSUBS VSUBS VSUBS VSUBS VSUBS VSUBS VSUBS
+ sky130_fd_sc_hd__o21ai_0
Xsky130_fd_sc_hd__nand2_1_7 VSUBS VSUBS VSUBS VSUBS VSUBS VSUBS VSUBS sky130_fd_sc_hd__nand2_1
Xsky130_fd_sc_hd__o21ai_0_24 VSUBS VSUBS VSUBS VSUBS sky130_fd_sc_hd__nand2_1_22/B
+ VSUBS VSUBS sky130_fd_sc_hd__o21ai_0_24/A2 VSUBS sky130_fd_sc_hd__o21ai_0
Xsky130_fd_sc_hd__o21ai_0_13 VSUBS VSUBS VSUBS VSUBS VSUBS VSUBS VSUBS VSUBS VSUBS
+ sky130_fd_sc_hd__o21ai_0
Xsky130_fd_sc_hd__decap_8_190 VSUBS VSUBS VSUBS VSUBS sky130_fd_sc_hd__decap_8
Xsky130_fd_sc_hd__a21oi_1_12 VSUBS VSUBS VSUBS VSUBS VSUBS VSUBS VSUBS VSUBS VSUBS
+ sky130_fd_sc_hd__a21oi_1
Xsky130_fd_sc_hd__a21oi_1_45 VSUBS VSUBS VSUBS VSUBS VSUBS VSUBS VSUBS VSUBS VSUBS
+ sky130_fd_sc_hd__a21oi_1
Xsky130_fd_sc_hd__a21oi_1_34 VSUBS VSUBS VSUBS VSUBS VSUBS VSUBS VSUBS VSUBS VSUBS
+ sky130_fd_sc_hd__a21oi_1
Xsky130_fd_sc_hd__inv_1_2 VSUBS VSUBS VSUBS VSUBS VSUBS VSUBS sky130_fd_sc_hd__inv_1
Xsky130_fd_sc_hd__a21oi_1_23 VSUBS VSUBS VSUBS VSUBS VSUBS sky130_fd_sc_hd__a21oi_1_23/A1
+ VSUBS VSUBS VSUBS sky130_fd_sc_hd__a21oi_1
Xsky130_fd_sc_hd__lpflow_inputiso1p_1_0 VSUBS VSUBS VSUBS VSUBS VSUBS VSUBS VSUBS
+ VSUBS sky130_fd_sc_hd__lpflow_inputiso1p_1
Xsky130_fd_sc_hd__nor3_1_4 VSUBS VSUBS VSUBS VSUBS VSUBS VSUBS VSUBS VSUBS sky130_fd_sc_hd__nor3_1
Xsky130_fd_sc_hd__decap_6_116 VSUBS VSUBS VSUBS VSUBS sky130_fd_sc_hd__decap_6
Xsky130_fd_sc_hd__decap_6_105 VSUBS VSUBS VSUBS VSUBS sky130_fd_sc_hd__decap_6
Xsky130_fd_sc_hd__decap_12_63 VSUBS VSUBS VSUBS VSUBS sky130_fd_sc_hd__decap_12
Xsky130_fd_sc_hd__decap_12_74 VSUBS VSUBS VSUBS VSUBS sky130_fd_sc_hd__decap_12
Xsky130_fd_sc_hd__decap_12_52 VSUBS VSUBS VSUBS VSUBS sky130_fd_sc_hd__decap_12
Xsky130_fd_sc_hd__decap_12_41 VSUBS VSUBS VSUBS VSUBS sky130_fd_sc_hd__decap_12
Xsky130_fd_sc_hd__decap_12_30 VSUBS VSUBS VSUBS VSUBS sky130_fd_sc_hd__decap_12
Xsky130_fd_sc_hd__decap_12_85 VSUBS VSUBS VSUBS VSUBS sky130_fd_sc_hd__decap_12
Xsky130_fd_sc_hd__decap_12_96 VSUBS VSUBS VSUBS VSUBS sky130_fd_sc_hd__decap_12
Xsky130_fd_sc_hd__decap_12_405 VSUBS VSUBS VSUBS VSUBS sky130_fd_sc_hd__decap_12
Xsky130_fd_sc_hd__decap_12_449 VSUBS VSUBS VSUBS VSUBS sky130_fd_sc_hd__decap_12
Xsky130_fd_sc_hd__decap_12_416 VSUBS VSUBS VSUBS VSUBS sky130_fd_sc_hd__decap_12
Xsky130_fd_sc_hd__decap_12_427 VSUBS VSUBS VSUBS VSUBS sky130_fd_sc_hd__decap_12
Xsky130_fd_sc_hd__decap_12_438 VSUBS VSUBS VSUBS VSUBS sky130_fd_sc_hd__decap_12
Xsky130_fd_sc_hd__a41oi_1_0 VSUBS VSUBS VSUBS VSUBS VSUBS VSUBS VSUBS VSUBS VSUBS
+ VSUBS VSUBS sky130_fd_sc_hd__a41oi_1
Xsky130_fd_sc_hd__decap_12_983 VSUBS VSUBS VSUBS VSUBS sky130_fd_sc_hd__decap_12
Xsky130_fd_sc_hd__decap_12_994 VSUBS VSUBS VSUBS VSUBS sky130_fd_sc_hd__decap_12
Xsky130_fd_sc_hd__decap_12_961 VSUBS VSUBS VSUBS VSUBS sky130_fd_sc_hd__decap_12
Xsky130_fd_sc_hd__decap_12_950 VSUBS VSUBS VSUBS VSUBS sky130_fd_sc_hd__decap_12
Xsky130_fd_sc_hd__decap_12_972 VSUBS VSUBS VSUBS VSUBS sky130_fd_sc_hd__decap_12
Xsky130_fd_sc_hd__decap_3_119 VSUBS VSUBS VSUBS VSUBS sky130_fd_sc_hd__decap_3
Xsky130_fd_sc_hd__decap_3_108 VSUBS VSUBS VSUBS VSUBS sky130_fd_sc_hd__decap_3
Xsky130_fd_sc_hd__decap_12_213 VSUBS VSUBS VSUBS VSUBS sky130_fd_sc_hd__decap_12
Xsky130_fd_sc_hd__decap_12_235 VSUBS VSUBS VSUBS VSUBS sky130_fd_sc_hd__decap_12
Xsky130_fd_sc_hd__decap_12_279 VSUBS VSUBS VSUBS VSUBS sky130_fd_sc_hd__decap_12
Xsky130_fd_sc_hd__decap_12_224 VSUBS VSUBS VSUBS VSUBS sky130_fd_sc_hd__decap_12
Xsky130_fd_sc_hd__decap_12_246 VSUBS VSUBS VSUBS VSUBS sky130_fd_sc_hd__decap_12
Xsky130_fd_sc_hd__decap_12_268 VSUBS VSUBS VSUBS VSUBS sky130_fd_sc_hd__decap_12
Xsky130_fd_sc_hd__decap_12_202 VSUBS VSUBS VSUBS VSUBS sky130_fd_sc_hd__decap_12
Xsky130_fd_sc_hd__decap_12_257 VSUBS VSUBS VSUBS VSUBS sky130_fd_sc_hd__decap_12
Xsky130_fd_sc_hd__xor2_1_1 VSUBS VSUBS VSUBS VSUBS VSUBS VSUBS VSUBS VSUBS VSUBS sky130_fd_sc_hd__xor2_1
Xsky130_fd_sc_hd__xor2_1_16 VSUBS VSUBS VSUBS VSUBS VSUBS VSUBS VSUBS VSUBS VSUBS
+ sky130_fd_sc_hd__xor2_1
Xsky130_fd_sc_hd__and3_1_3 VSUBS VSUBS VSUBS VSUBS sky130_fd_sc_hd__and3_1_3/X VSUBS
+ VSUBS VSUBS VSUBS sky130_fd_sc_hd__and3_1
Xsky130_fd_sc_hd__decap_12_791 VSUBS VSUBS VSUBS VSUBS sky130_fd_sc_hd__decap_12
Xsky130_fd_sc_hd__decap_12_780 VSUBS VSUBS VSUBS VSUBS sky130_fd_sc_hd__decap_12
Xsky130_fd_sc_hd__decap_6_12 VSUBS VSUBS VSUBS VSUBS sky130_fd_sc_hd__decap_6
Xsky130_fd_sc_hd__decap_6_23 VSUBS VSUBS VSUBS VSUBS sky130_fd_sc_hd__decap_6
Xsky130_fd_sc_hd__decap_6_78 VSUBS VSUBS VSUBS VSUBS sky130_fd_sc_hd__decap_6
Xsky130_fd_sc_hd__decap_6_67 VSUBS VSUBS VSUBS VSUBS sky130_fd_sc_hd__decap_6
Xsky130_fd_sc_hd__decap_6_89 VSUBS VSUBS VSUBS VSUBS sky130_fd_sc_hd__decap_6
Xsky130_fd_sc_hd__decap_6_56 VSUBS VSUBS VSUBS VSUBS sky130_fd_sc_hd__decap_6
Xsky130_fd_sc_hd__decap_6_34 VSUBS VSUBS VSUBS VSUBS sky130_fd_sc_hd__decap_6
Xsky130_fd_sc_hd__decap_6_45 VSUBS VSUBS VSUBS VSUBS sky130_fd_sc_hd__decap_6
Xsky130_fd_sc_hd__o21ai_0_3 VSUBS VSUBS VSUBS VSUBS VSUBS VSUBS VSUBS VSUBS VSUBS
+ sky130_fd_sc_hd__o21ai_0
Xsky130_fd_sc_hd__clkinv_1_6 VSUBS VSUBS VSUBS VSUBS VSUBS VSUBS sky130_fd_sc_hd__clkinv_1
Xsky130_fd_sc_hd__decap_12_1064 VSUBS VSUBS VSUBS VSUBS sky130_fd_sc_hd__decap_12
Xsky130_fd_sc_hd__decap_12_1097 VSUBS VSUBS VSUBS VSUBS sky130_fd_sc_hd__decap_12
Xsky130_fd_sc_hd__decap_12_1053 VSUBS VSUBS VSUBS VSUBS sky130_fd_sc_hd__decap_12
Xsky130_fd_sc_hd__decap_12_1020 VSUBS VSUBS VSUBS VSUBS sky130_fd_sc_hd__decap_12
Xsky130_fd_sc_hd__decap_12_1031 VSUBS VSUBS VSUBS VSUBS sky130_fd_sc_hd__decap_12
Xsky130_fd_sc_hd__decap_12_1075 VSUBS VSUBS VSUBS VSUBS sky130_fd_sc_hd__decap_12
Xsky130_fd_sc_hd__decap_12_1086 VSUBS VSUBS VSUBS VSUBS sky130_fd_sc_hd__decap_12
Xsky130_fd_sc_hd__decap_12_1042 VSUBS VSUBS VSUBS VSUBS sky130_fd_sc_hd__decap_12
Xsky130_fd_sc_hd__dfxtp_1_85 VSUBS VSUBS VSUBS VSUBS VSUBS VSUBS VSUBS sky130_fd_sc_hd__dfxtp_1_85/a_975_413#
+ VSUBS VSUBS sky130_fd_sc_hd__dfxtp_1_85/a_592_47# VSUBS VSUBS sky130_fd_sc_hd__dfxtp_1_85/a_561_413#
+ VSUBS VSUBS VSUBS sky130_fd_sc_hd__dfxtp_1
Xsky130_fd_sc_hd__dfxtp_1_74 VSUBS VSUBS VSUBS VSUBS VSUBS VSUBS VSUBS sky130_fd_sc_hd__dfxtp_1_74/a_975_413#
+ VSUBS VSUBS sky130_fd_sc_hd__dfxtp_1_74/a_592_47# VSUBS VSUBS sky130_fd_sc_hd__dfxtp_1_74/a_561_413#
+ VSUBS VSUBS VSUBS sky130_fd_sc_hd__dfxtp_1
Xsky130_fd_sc_hd__dfxtp_1_52 VSUBS VSUBS VSUBS VSUBS VSUBS VSUBS VSUBS VSUBS VSUBS
+ VSUBS sky130_fd_sc_hd__dfxtp_1_52/a_592_47# VSUBS VSUBS sky130_fd_sc_hd__dfxtp_1_52/a_561_413#
+ VSUBS VSUBS VSUBS sky130_fd_sc_hd__dfxtp_1
Xsky130_fd_sc_hd__dfxtp_1_63 VSUBS VSUBS VSUBS VSUBS VSUBS VSUBS VSUBS sky130_fd_sc_hd__dfxtp_1_63/a_975_413#
+ VSUBS VSUBS sky130_fd_sc_hd__dfxtp_1_63/a_592_47# VSUBS VSUBS sky130_fd_sc_hd__dfxtp_1_63/a_561_413#
+ VSUBS VSUBS VSUBS sky130_fd_sc_hd__dfxtp_1
Xsky130_fd_sc_hd__dfxtp_1_41 VSUBS VSUBS VSUBS VSUBS VSUBS VSUBS VSUBS sky130_fd_sc_hd__dfxtp_1_41/a_975_413#
+ VSUBS VSUBS sky130_fd_sc_hd__dfxtp_1_41/a_592_47# VSUBS VSUBS sky130_fd_sc_hd__dfxtp_1_41/a_561_413#
+ VSUBS VSUBS VSUBS sky130_fd_sc_hd__dfxtp_1
Xsky130_fd_sc_hd__dfxtp_1_30 VSUBS VSUBS VSUBS VSUBS VSUBS VSUBS VSUBS sky130_fd_sc_hd__dfxtp_1_30/a_975_413#
+ VSUBS VSUBS sky130_fd_sc_hd__dfxtp_1_30/a_592_47# VSUBS VSUBS sky130_fd_sc_hd__dfxtp_1_30/a_561_413#
+ VSUBS VSUBS VSUBS sky130_fd_sc_hd__dfxtp_1
Xsky130_fd_sc_hd__dfxtp_1_96 VSUBS VSUBS VSUBS VSUBS VSUBS VSUBS VSUBS sky130_fd_sc_hd__dfxtp_1_96/a_975_413#
+ VSUBS VSUBS sky130_fd_sc_hd__dfxtp_1_96/a_592_47# VSUBS VSUBS sky130_fd_sc_hd__dfxtp_1_96/a_561_413#
+ VSUBS VSUBS VSUBS sky130_fd_sc_hd__dfxtp_1
Xsky130_fd_sc_hd__mux2i_1_7 VSUBS VSUBS VSUBS VSUBS VSUBS VSUBS VSUBS VSUBS VSUBS
+ VSUBS VSUBS VSUBS sky130_fd_sc_hd__mux2i_1
Xsky130_fd_sc_hd__decap_3_57 VSUBS VSUBS VSUBS VSUBS sky130_fd_sc_hd__decap_3
Xsky130_fd_sc_hd__decap_3_24 VSUBS VSUBS VSUBS VSUBS sky130_fd_sc_hd__decap_3
Xsky130_fd_sc_hd__decap_3_13 VSUBS VSUBS VSUBS VSUBS sky130_fd_sc_hd__decap_3
Xsky130_fd_sc_hd__decap_3_79 VSUBS VSUBS VSUBS VSUBS sky130_fd_sc_hd__decap_3
Xsky130_fd_sc_hd__decap_3_68 VSUBS VSUBS VSUBS VSUBS sky130_fd_sc_hd__decap_3
Xsky130_fd_sc_hd__decap_3_46 VSUBS VSUBS VSUBS VSUBS sky130_fd_sc_hd__decap_3
Xsky130_fd_sc_hd__decap_3_35 VSUBS VSUBS VSUBS VSUBS sky130_fd_sc_hd__decap_3
Xsky130_fd_sc_hd__dfxtp_1_3 VSUBS VSUBS VSUBS VSUBS VSUBS VSUBS VSUBS sky130_fd_sc_hd__dfxtp_1_3/a_975_413#
+ VSUBS VSUBS sky130_fd_sc_hd__dfxtp_1_3/a_592_47# VSUBS VSUBS sky130_fd_sc_hd__dfxtp_1_3/a_561_413#
+ VSUBS VSUBS VSUBS sky130_fd_sc_hd__dfxtp_1
Xsky130_fd_sc_hd__edfxtp_1_6 VSUBS VSUBS VSUBS VSUBS VSUBS VSUBS VSUBS VSUBS sky130_fd_sc_hd__edfxtp_1_6/a_1717_47#
+ sky130_fd_sc_hd__edfxtp_1_6/a_1514_47# VSUBS sky130_fd_sc_hd__edfxtp_1_6/a_1500_413#
+ sky130_fd_sc_hd__edfxtp_1_6/a_729_47# VSUBS VSUBS VSUBS VSUBS sky130_fd_sc_hd__edfxtp_1_6/a_729_369#
+ VSUBS sky130_fd_sc_hd__edfxtp_1_6/a_1675_413# VSUBS VSUBS sky130_fd_sc_hd__edfxtp_1
Xsky130_fd_sc_hd__decap_12_609 VSUBS VSUBS VSUBS VSUBS sky130_fd_sc_hd__decap_12
Xsky130_fd_sc_hd__o21ai_0_14 VSUBS VSUBS VSUBS VSUBS VSUBS VSUBS VSUBS VSUBS VSUBS
+ sky130_fd_sc_hd__o21ai_0
Xsky130_fd_sc_hd__o21ai_0_58 VSUBS VSUBS VSUBS VSUBS VSUBS VSUBS VSUBS VSUBS VSUBS
+ sky130_fd_sc_hd__o21ai_0
Xsky130_fd_sc_hd__o21ai_0_47 VSUBS VSUBS VSUBS VSUBS VSUBS sky130_fd_sc_hd__o21ai_0_48/A1
+ VSUBS VSUBS VSUBS sky130_fd_sc_hd__o21ai_0
Xsky130_fd_sc_hd__o21ai_0_36 VSUBS VSUBS VSUBS VSUBS VSUBS VSUBS VSUBS VSUBS VSUBS
+ sky130_fd_sc_hd__o21ai_0
Xsky130_fd_sc_hd__nand2_1_8 VSUBS VSUBS VSUBS VSUBS VSUBS VSUBS VSUBS sky130_fd_sc_hd__nand2_1
Xsky130_fd_sc_hd__o21ai_0_25 VSUBS VSUBS VSUBS VSUBS VSUBS VSUBS VSUBS VSUBS VSUBS
+ sky130_fd_sc_hd__o21ai_0
Xsky130_fd_sc_hd__decap_8_180 VSUBS VSUBS VSUBS VSUBS sky130_fd_sc_hd__decap_8
Xsky130_fd_sc_hd__decap_8_191 VSUBS VSUBS VSUBS VSUBS sky130_fd_sc_hd__decap_8
Xsky130_fd_sc_hd__a21oi_1_46 VSUBS VSUBS VSUBS VSUBS VSUBS VSUBS VSUBS VSUBS VSUBS
+ sky130_fd_sc_hd__a21oi_1
Xsky130_fd_sc_hd__a21oi_1_35 VSUBS VSUBS VSUBS VSUBS VSUBS VSUBS VSUBS VSUBS VSUBS
+ sky130_fd_sc_hd__a21oi_1
Xsky130_fd_sc_hd__a21oi_1_24 VSUBS VSUBS VSUBS VSUBS VSUBS VSUBS VSUBS VSUBS VSUBS
+ sky130_fd_sc_hd__a21oi_1
Xsky130_fd_sc_hd__a21oi_1_13 VSUBS VSUBS VSUBS VSUBS VSUBS VSUBS VSUBS VSUBS VSUBS
+ sky130_fd_sc_hd__a21oi_1
Xsky130_fd_sc_hd__decap_6_106 VSUBS VSUBS VSUBS VSUBS sky130_fd_sc_hd__decap_6
Xsky130_fd_sc_hd__decap_12_20 VSUBS VSUBS VSUBS VSUBS sky130_fd_sc_hd__decap_12
Xsky130_fd_sc_hd__lpflow_inputiso1p_1_1 VSUBS VSUBS VSUBS VSUBS VSUBS VSUBS VSUBS
+ VSUBS sky130_fd_sc_hd__lpflow_inputiso1p_1
Xsky130_fd_sc_hd__nor3_1_5 VSUBS VSUBS VSUBS VSUBS VSUBS VSUBS VSUBS VSUBS sky130_fd_sc_hd__nor3_1
Xsky130_fd_sc_hd__decap_6_117 VSUBS VSUBS VSUBS VSUBS sky130_fd_sc_hd__decap_6
Xsky130_fd_sc_hd__decap_12_53 VSUBS VSUBS VSUBS VSUBS sky130_fd_sc_hd__decap_12
Xsky130_fd_sc_hd__decap_12_64 VSUBS VSUBS VSUBS VSUBS sky130_fd_sc_hd__decap_12
Xsky130_fd_sc_hd__decap_12_75 VSUBS VSUBS VSUBS VSUBS sky130_fd_sc_hd__decap_12
Xsky130_fd_sc_hd__decap_12_97 VSUBS VSUBS VSUBS VSUBS sky130_fd_sc_hd__decap_12
Xsky130_fd_sc_hd__decap_12_86 VSUBS VSUBS VSUBS VSUBS sky130_fd_sc_hd__decap_12
Xsky130_fd_sc_hd__decap_12_31 VSUBS VSUBS VSUBS VSUBS sky130_fd_sc_hd__decap_12
Xsky130_fd_sc_hd__decap_12_42 VSUBS VSUBS VSUBS VSUBS sky130_fd_sc_hd__decap_12
Xsky130_fd_sc_hd__o311ai_0_0 VSUBS VSUBS VSUBS VSUBS VSUBS VSUBS VSUBS VSUBS VSUBS
+ VSUBS VSUBS sky130_fd_sc_hd__o311ai_0
Xsky130_fd_sc_hd__decap_12_406 VSUBS VSUBS VSUBS VSUBS sky130_fd_sc_hd__decap_12
Xsky130_fd_sc_hd__decap_12_439 VSUBS VSUBS VSUBS VSUBS sky130_fd_sc_hd__decap_12
Xsky130_fd_sc_hd__decap_12_417 VSUBS VSUBS VSUBS VSUBS sky130_fd_sc_hd__decap_12
Xsky130_fd_sc_hd__decap_12_428 VSUBS VSUBS VSUBS VSUBS sky130_fd_sc_hd__decap_12
Xsky130_fd_sc_hd__decap_12_984 VSUBS VSUBS VSUBS VSUBS sky130_fd_sc_hd__decap_12
Xsky130_fd_sc_hd__decap_12_995 VSUBS VSUBS VSUBS VSUBS sky130_fd_sc_hd__decap_12
Xsky130_fd_sc_hd__decap_12_962 VSUBS VSUBS VSUBS VSUBS sky130_fd_sc_hd__decap_12
Xsky130_fd_sc_hd__decap_12_951 VSUBS VSUBS VSUBS VSUBS sky130_fd_sc_hd__decap_12
Xsky130_fd_sc_hd__decap_12_973 VSUBS VSUBS VSUBS VSUBS sky130_fd_sc_hd__decap_12
Xsky130_fd_sc_hd__decap_12_940 VSUBS VSUBS VSUBS VSUBS sky130_fd_sc_hd__decap_12
Xsky130_fd_sc_hd__decap_3_109 VSUBS VSUBS VSUBS VSUBS sky130_fd_sc_hd__decap_3
Xsky130_fd_sc_hd__decap_12_214 VSUBS VSUBS VSUBS VSUBS sky130_fd_sc_hd__decap_12
Xsky130_fd_sc_hd__decap_12_225 VSUBS VSUBS VSUBS VSUBS sky130_fd_sc_hd__decap_12
Xsky130_fd_sc_hd__decap_12_203 VSUBS VSUBS VSUBS VSUBS sky130_fd_sc_hd__decap_12
Xsky130_fd_sc_hd__decap_12_269 VSUBS VSUBS VSUBS VSUBS sky130_fd_sc_hd__decap_12
Xsky130_fd_sc_hd__decap_12_236 VSUBS VSUBS VSUBS VSUBS sky130_fd_sc_hd__decap_12
Xsky130_fd_sc_hd__decap_12_247 VSUBS VSUBS VSUBS VSUBS sky130_fd_sc_hd__decap_12
Xsky130_fd_sc_hd__decap_12_258 VSUBS VSUBS VSUBS VSUBS sky130_fd_sc_hd__decap_12
Xsky130_fd_sc_hd__xor2_1_2 VSUBS VSUBS VSUBS VSUBS sky130_fd_sc_hd__xor2_1_2/A VSUBS
+ VSUBS VSUBS VSUBS sky130_fd_sc_hd__xor2_1
Xsky130_fd_sc_hd__decap_12_770 VSUBS VSUBS VSUBS VSUBS sky130_fd_sc_hd__decap_12
Xsky130_fd_sc_hd__and3_1_4 VSUBS VSUBS VSUBS VSUBS VSUBS VSUBS VSUBS VSUBS VSUBS sky130_fd_sc_hd__and3_1
Xsky130_fd_sc_hd__decap_12_781 VSUBS VSUBS VSUBS VSUBS sky130_fd_sc_hd__decap_12
Xsky130_fd_sc_hd__decap_12_792 VSUBS VSUBS VSUBS VSUBS sky130_fd_sc_hd__decap_12
.ends
