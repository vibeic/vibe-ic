* NGSPICE file created from chip_top.ext - technology: sky130A

* Black-box entry subcircuit for sky130_fd_sc_hd__decap_12 abstract view
.subckt sky130_fd_sc_hd__decap_12 VGND VNB VPB VPWR
.ends

* Black-box entry subcircuit for sky130_fd_sc_hd__decap_6 abstract view
.subckt sky130_fd_sc_hd__decap_6 VGND VNB VPB VPWR
.ends

* Black-box entry subcircuit for sky130_fd_sc_hd__nand3_1 abstract view
.subckt sky130_fd_sc_hd__nand3_1 A B C VGND VNB VPB VPWR Y
.ends

* Black-box entry subcircuit for sky130_fd_sc_hd__decap_3 abstract view
.subckt sky130_fd_sc_hd__decap_3 VGND VNB VPB VPWR
.ends

* Black-box entry subcircuit for sky130_fd_sc_hd__tapvpwrvgnd_1 abstract view
.subckt sky130_fd_sc_hd__tapvpwrvgnd_1 VGND VPWR
.ends

* Black-box entry subcircuit for sky130_fd_sc_hd__decap_8 abstract view
.subckt sky130_fd_sc_hd__decap_8 VGND VNB VPB VPWR
.ends

* Black-box entry subcircuit for sky130_fd_sc_hd__fill_1 abstract view
.subckt sky130_fd_sc_hd__fill_1 VGND VNB VPB VPWR
.ends

* Black-box entry subcircuit for sky130_fd_sc_hd__dfxtp_1 abstract view
.subckt sky130_fd_sc_hd__dfxtp_1 CLK D VGND VNB VPB VPWR Q
.ends

* Black-box entry subcircuit for sky130_fd_sc_hd__fill_2 abstract view
.subckt sky130_fd_sc_hd__fill_2 VGND VNB VPB VPWR
.ends

* Black-box entry subcircuit for sky130_fd_sc_hd__decap_4 abstract view
.subckt sky130_fd_sc_hd__decap_4 VGND VNB VPB VPWR
.ends

* Black-box entry subcircuit for sky130_fd_sc_hd__nand2b_1 abstract view
.subckt sky130_fd_sc_hd__nand2b_1 A_N B VGND VNB VPB VPWR Y
.ends

* Black-box entry subcircuit for sky130_fd_sc_hd__edfxtp_1 abstract view
.subckt sky130_fd_sc_hd__edfxtp_1 CLK D DE VGND VNB VPB VPWR Q
.ends

* Black-box entry subcircuit for sky130_fd_sc_hd__xor2_1 abstract view
.subckt sky130_fd_sc_hd__xor2_1 A B VGND VNB VPB VPWR X
.ends

* Black-box entry subcircuit for sky130_fd_sc_hd__nor2_1 abstract view
.subckt sky130_fd_sc_hd__nor2_1 A B VGND VNB VPB VPWR Y
.ends

* Black-box entry subcircuit for sky130_fd_sc_hd__o21ai_0 abstract view
.subckt sky130_fd_sc_hd__o21ai_0 A1 A2 B1 VGND VNB VPB VPWR Y
.ends

* Black-box entry subcircuit for sky130_fd_sc_hd__xnor2_1 abstract view
.subckt sky130_fd_sc_hd__xnor2_1 A B VGND VNB VPB VPWR Y
.ends

* Black-box entry subcircuit for sky130_fd_sc_hd__a31oi_1 abstract view
.subckt sky130_fd_sc_hd__a31oi_1 A1 A2 A3 B1 VGND VNB VPB VPWR Y
.ends

* Black-box entry subcircuit for sky130_fd_sc_hd__nand4_1 abstract view
.subckt sky130_fd_sc_hd__nand4_1 A B C D VGND VNB VPB VPWR Y
.ends

* Black-box entry subcircuit for sky130_fd_sc_hd__clkbuf_16 abstract view
.subckt sky130_fd_sc_hd__clkbuf_16 A VGND VNB VPB VPWR X
.ends

* Black-box entry subcircuit for sky130_fd_sc_hd__clkinv_1 abstract view
.subckt sky130_fd_sc_hd__clkinv_1 A VGND VNB VPB VPWR Y
.ends

* Black-box entry subcircuit for sky130_fd_sc_hd__a21oi_1 abstract view
.subckt sky130_fd_sc_hd__a21oi_1 A1 A2 B1 VGND VNB VPB VPWR Y
.ends

* Black-box entry subcircuit for sky130_fd_sc_hd__o211ai_1 abstract view
.subckt sky130_fd_sc_hd__o211ai_1 A1 A2 B1 C1 VGND VNB VPB VPWR Y
.ends

* Black-box entry subcircuit for sky130_fd_sc_hd__a22oi_1 abstract view
.subckt sky130_fd_sc_hd__a22oi_1 A1 A2 B1 B2 VGND VNB VPB VPWR Y
.ends

* Black-box entry subcircuit for sky130_fd_sc_hd__mux2i_1 abstract view
.subckt sky130_fd_sc_hd__mux2i_1 A0 A1 S VGND VNB VPB VPWR Y
.ends

* Black-box entry subcircuit for sky130_fd_sc_hd__nand2_1 abstract view
.subckt sky130_fd_sc_hd__nand2_1 A B VGND VNB VPB VPWR Y
.ends

* Black-box entry subcircuit for sky130_fd_sc_hd__o311ai_0 abstract view
.subckt sky130_fd_sc_hd__o311ai_0 A1 A2 A3 B1 C1 VGND VNB VPB VPWR Y
.ends

* Black-box entry subcircuit for sky130_fd_sc_hd__a222oi_1 abstract view
.subckt sky130_fd_sc_hd__a222oi_1 A1 A2 B1 B2 C1 C2 VGND VNB VPB VPWR Y
.ends

* Black-box entry subcircuit for sky130_fd_sc_hd__nor3_1 abstract view
.subckt sky130_fd_sc_hd__nor3_1 A B C VGND VNB VPB VPWR Y
.ends

* Black-box entry subcircuit for sky130_fd_sc_hd__a32oi_1 abstract view
.subckt sky130_fd_sc_hd__a32oi_1 A1 A2 A3 B1 B2 VGND VNB VPB VPWR Y
.ends

* Black-box entry subcircuit for sky130_fd_sc_hd__inv_1 abstract view
.subckt sky130_fd_sc_hd__inv_1 A VGND VNB VPB VPWR Y
.ends

* Black-box entry subcircuit for sky130_fd_sc_hd__a2bb2oi_1 abstract view
.subckt sky130_fd_sc_hd__a2bb2oi_1 A1_N A2_N B1 B2 VGND VNB VPB VPWR Y
.ends

* Black-box entry subcircuit for sky130_fd_sc_hd__inv_6 abstract view
.subckt sky130_fd_sc_hd__inv_6 A VGND VNB VPB VPWR Y
.ends

* Black-box entry subcircuit for sky130_fd_sc_hd__nor4_1 abstract view
.subckt sky130_fd_sc_hd__nor4_1 A B C D VGND VNB VPB VPWR Y
.ends

* Black-box entry subcircuit for sky130_fd_sc_hd__and3_1 abstract view
.subckt sky130_fd_sc_hd__and3_1 A B C VGND VNB VPB VPWR X
.ends

* Black-box entry subcircuit for sky130_fd_sc_hd__nor2b_1 abstract view
.subckt sky130_fd_sc_hd__nor2b_1 A B_N VGND VNB VPB VPWR Y
.ends

* Black-box entry subcircuit for sky130_fd_sc_hd__clkbuf_4 abstract view
.subckt sky130_fd_sc_hd__clkbuf_4 A VGND VNB VPB VPWR X
.ends

* Black-box entry subcircuit for sky130_fd_sc_hd__a21bo_1 abstract view
.subckt sky130_fd_sc_hd__a21bo_1 A1 A2 B1_N VGND VNB VPB VPWR X
.ends

* Black-box entry subcircuit for sky130_fd_sc_hd__o21a_1 abstract view
.subckt sky130_fd_sc_hd__o21a_1 A1 A2 B1 VGND VNB VPB VPWR X
.ends

* Black-box entry subcircuit for sky130_fd_sc_hd__and2_0 abstract view
.subckt sky130_fd_sc_hd__and2_0 A B VGND VNB VPB VPWR X
.ends

* Black-box entry subcircuit for sky130_fd_sc_hd__buf_8 abstract view
.subckt sky130_fd_sc_hd__buf_8 A VGND VNB VPB VPWR X
.ends

* Black-box entry subcircuit for sky130_fd_sc_hd__conb_1 abstract view
.subckt sky130_fd_sc_hd__conb_1 VGND VNB VPB VPWR HI LO
.ends

* Black-box entry subcircuit for sky130_fd_sc_hd__a21boi_0 abstract view
.subckt sky130_fd_sc_hd__a21boi_0 A1 A2 B1_N VGND VNB VPB VPWR Y
.ends

* Black-box entry subcircuit for sky130_fd_sc_hd__o31a_1 abstract view
.subckt sky130_fd_sc_hd__o31a_1 A1 A2 A3 B1 VGND VNB VPB VPWR X
.ends

* Black-box entry subcircuit for sky130_fd_sc_hd__o22ai_1 abstract view
.subckt sky130_fd_sc_hd__o22ai_1 A1 A2 B1 B2 VGND VNB VPB VPWR Y
.ends

* Black-box entry subcircuit for sky130_fd_sc_hd__nor4bb_1 abstract view
.subckt sky130_fd_sc_hd__nor4bb_1 A B C_N D_N VGND VNB VPB VPWR Y
.ends

* Black-box entry subcircuit for sky130_fd_sc_hd__clkinvlp_4 abstract view
.subckt sky130_fd_sc_hd__clkinvlp_4 A VGND VNB VPB VPWR Y
.ends

* Black-box entry subcircuit for sky130_fd_sc_hd__dfrtp_1 abstract view
.subckt sky130_fd_sc_hd__dfrtp_1 CLK D RESET_B VGND VNB VPB VPWR Q
.ends

* Black-box entry subcircuit for sky130_fd_sc_hd__nor4b_1 abstract view
.subckt sky130_fd_sc_hd__nor4b_1 A B C D_N VGND VNB VPB VPWR Y
.ends

* Black-box entry subcircuit for sky130_fd_sc_hd__o221ai_1 abstract view
.subckt sky130_fd_sc_hd__o221ai_1 A1 A2 B1 B2 C1 VGND VNB VPB VPWR Y
.ends

* Black-box entry subcircuit for sky130_fd_sc_hd__lpflow_isobufsrc_1 abstract view
.subckt sky130_fd_sc_hd__lpflow_isobufsrc_1 A SLEEP VGND VNB VPB VPWR X
.ends

* Black-box entry subcircuit for sky130_fd_sc_hd__mux2_1 abstract view
.subckt sky130_fd_sc_hd__mux2_1 A0 A1 S VGND VNB VPB VPWR X
.ends

* Black-box entry subcircuit for sky130_fd_sc_hd__o31ai_1 abstract view
.subckt sky130_fd_sc_hd__o31ai_1 A1 A2 A3 B1 VGND VNB VPB VPWR Y
.ends

* Black-box entry subcircuit for sky130_fd_sc_hd__a211oi_1 abstract view
.subckt sky130_fd_sc_hd__a211oi_1 A1 A2 B1 C1 VGND VNB VPB VPWR Y
.ends

* Black-box entry subcircuit for sky130_fd_sc_hd__o21ba_1 abstract view
.subckt sky130_fd_sc_hd__o21ba_1 A1 A2 B1_N VGND VNB VPB VPWR X
.ends

* Black-box entry subcircuit for sky130_fd_sc_hd__nor3b_1 abstract view
.subckt sky130_fd_sc_hd__nor3b_1 A B C_N VGND VNB VPB VPWR Y
.ends

* Black-box entry subcircuit for sky130_fd_sc_hd__a41oi_1 abstract view
.subckt sky130_fd_sc_hd__a41oi_1 A1 A2 A3 A4 B1 VGND VNB VPB VPWR Y
.ends

* Black-box entry subcircuit for sky130_fd_sc_hd__lpflow_inputiso1p_1 abstract view
.subckt sky130_fd_sc_hd__lpflow_inputiso1p_1 A SLEEP VGND VNB VPB VPWR X
.ends

* Black-box entry subcircuit for sky130_fd_sc_hd__or3_1 abstract view
.subckt sky130_fd_sc_hd__or3_1 A B C VGND VNB VPB VPWR X
.ends

* Black-box entry subcircuit for sky130_fd_sc_hd__or4_1 abstract view
.subckt sky130_fd_sc_hd__or4_1 A B C D VGND VNB VPB VPWR X
.ends

* Black-box entry subcircuit for sky130_fd_sc_hd__and2_1 abstract view
.subckt sky130_fd_sc_hd__and2_1 A B VGND VNB VPB VPWR X
.ends

* Black-box entry subcircuit for sky130_fd_sc_hd__or4b_1 abstract view
.subckt sky130_fd_sc_hd__or4b_1 A B C D_N VGND VNB VPB VPWR X
.ends

* Black-box entry subcircuit for sky130_fd_sc_hd__o41ai_1 abstract view
.subckt sky130_fd_sc_hd__o41ai_1 A1 A2 A3 A4 B1 VGND VNB VPB VPWR Y
.ends

.subckt chip_top CH_ENABLE[0] CH_ENABLE[1] CH_ENABLE[2] CH_ENABLE[3] CH_FLASH_READY
+ CH_OOB_READY CH_PC_READY CH_VW_READY CRC_ERROR ESPI_ALERT_N ESPI_BIT_TICK ESPI_CS_N
+ ESPI_IO0_IN ESPI_IO1_OUT ESPI_IO_MODE[0] ESPI_IO_MODE[1] ESPI_RESET_N EVENT_PENDING
+ LAST_CMD[0] LAST_CMD[1] LAST_CMD[2] LAST_CMD[3] LAST_CMD[4] LAST_CMD[5] LAST_CMD[6]
+ LAST_CMD[7] STATUS_REG[0] STATUS_REG[10] STATUS_REG[11] STATUS_REG[12] STATUS_REG[13]
+ STATUS_REG[14] STATUS_REG[15] STATUS_REG[1] STATUS_REG[2] STATUS_REG[3] STATUS_REG[4]
+ STATUS_REG[5] STATUS_REG[6] STATUS_REG[7] STATUS_REG[8] STATUS_REG[9] clk rst_n
XFILLER_54_247 VSUBS VSUBS _999_/VPB _999_/VPB sky130_fd_sc_hd__decap_12
XFILLER_54_203 VSUBS VSUBS _999_/VPB _999_/VPB sky130_fd_sc_hd__decap_6
XFILLER_13_133 VSUBS VSUBS _999_/VPB _999_/VPB sky130_fd_sc_hd__decap_12
X_501_ _975_/Q _979_/Q _873_/B VSUBS VSUBS _999_/VPB _999_/VPB _503_/B sky130_fd_sc_hd__nand3_1
XFILLER_13_177 VSUBS VSUBS _999_/VPB _999_/VPB sky130_fd_sc_hd__decap_3
XFILLER_5_332 VSUBS VSUBS _999_/VPB _999_/VPB sky130_fd_sc_hd__decap_6
XFILLER_3_34 VSUBS VSUBS _999_/VPB _999_/VPB sky130_fd_sc_hd__decap_12
XFILLER_3_12 VSUBS VSUBS _999_/VPB _999_/VPB sky130_fd_sc_hd__decap_6
XFILLER_36_247 VSUBS VSUBS _999_/VPB _999_/VPB sky130_fd_sc_hd__decap_12
XFILLER_51_228 VSUBS VSUBS _999_/VPB _999_/VPB sky130_fd_sc_hd__decap_12
XTAP_TAPCELL_ROW_46_286 VSUBS _999_/VPB sky130_fd_sc_hd__tapvpwrvgnd_1
XFILLER_59_328 VSUBS VSUBS _999_/VPB _999_/VPB sky130_fd_sc_hd__decap_8
XTAP_TAPCELL_ROW_37_231 VSUBS _999_/VPB sky130_fd_sc_hd__tapvpwrvgnd_1
XFILLER_10_103 VSUBS VSUBS _999_/VPB _999_/VPB sky130_fd_sc_hd__decap_12
XFILLER_10_147 VSUBS VSUBS _999_/VPB _999_/VPB sky130_fd_sc_hd__decap_3
XFILLER_10_169 VSUBS VSUBS _999_/VPB _999_/VPB sky130_fd_sc_hd__fill_1
XFILLER_12_43 VSUBS VSUBS _999_/VPB _999_/VPB sky130_fd_sc_hd__decap_12
XTAP_TAPCELL_ROW_20_131 VSUBS _999_/VPB sky130_fd_sc_hd__tapvpwrvgnd_1
XFILLER_12_87 VSUBS VSUBS _999_/VPB _999_/VPB sky130_fd_sc_hd__decap_3
X_981_ _981_/CLK _981_/D VSUBS VSUBS _999_/VPB _999_/VPB _981_/Q sky130_fd_sc_hd__dfxtp_1
XFILLER_37_73 VSUBS VSUBS _999_/VPB _999_/VPB sky130_fd_sc_hd__decap_12
XFILLER_53_61 VSUBS VSUBS _999_/VPB _999_/VPB sky130_fd_sc_hd__decap_12
XTAP_TAPCELL_ROW_43_267 VSUBS _999_/VPB sky130_fd_sc_hd__tapvpwrvgnd_1
XFILLER_33_228 VSUBS VSUBS _999_/VPB _999_/VPB sky130_fd_sc_hd__fill_1
XFILLER_33_217 VSUBS VSUBS _999_/VPB _999_/VPB sky130_fd_sc_hd__fill_2
XTAP_TAPCELL_ROW_8_55 VSUBS _999_/VPB sky130_fd_sc_hd__tapvpwrvgnd_1
XFILLER_18_269 VSUBS VSUBS _999_/VPB _999_/VPB sky130_fd_sc_hd__fill_1
XFILLER_49_361 VSUBS VSUBS _999_/VPB _999_/VPB sky130_fd_sc_hd__decap_8
XTAP_TAPCELL_ROW_34_212 VSUBS _999_/VPB sky130_fd_sc_hd__tapvpwrvgnd_1
XFILLER_24_217 VSUBS VSUBS _999_/VPB _999_/VPB sky130_fd_sc_hd__decap_4
XFILLER_59_169 VSUBS VSUBS _999_/VPB _999_/VPB sky130_fd_sc_hd__decap_8
XTAP_TAPCELL_ROW_57_348 VSUBS _999_/VPB sky130_fd_sc_hd__tapvpwrvgnd_1
XFILLER_15_239 VSUBS VSUBS _999_/VPB _999_/VPB sky130_fd_sc_hd__fill_1
XTAP_TAPCELL_ROW_40_248 VSUBS _999_/VPB sky130_fd_sc_hd__tapvpwrvgnd_1
XFILLER_23_97 VSUBS VSUBS _999_/VPB _999_/VPB sky130_fd_sc_hd__decap_8
XFILLER_23_294 VSUBS VSUBS _999_/VPB _999_/VPB sky130_fd_sc_hd__decap_6
XFILLER_2_187 VSUBS VSUBS _999_/VPB _999_/VPB sky130_fd_sc_hd__decap_12
X_895_ _981_/CLK _895_/D VSUBS VSUBS _999_/VPB _999_/VPB _895_/Q sky130_fd_sc_hd__dfxtp_1
X_964_ _970_/CLK _964_/D VSUBS VSUBS _999_/VPB _999_/VPB _964_/Q sky130_fd_sc_hd__dfxtp_1
XFILLER_61_301 VSUBS VSUBS _999_/VPB _999_/VPB sky130_fd_sc_hd__decap_12
XFILLER_46_331 VSUBS VSUBS _999_/VPB _999_/VPB sky130_fd_sc_hd__decap_4
XFILLER_0_24 VSUBS VSUBS _999_/VPB _999_/VPB sky130_fd_sc_hd__decap_6
XFILLER_21_209 VSUBS VSUBS _999_/VPB _999_/VPB sky130_fd_sc_hd__decap_12
XFILLER_56_139 VSUBS VSUBS _999_/VPB _999_/VPB sky130_fd_sc_hd__decap_6
XFILLER_29_0 VSUBS VSUBS _999_/VPB _999_/VPB sky130_fd_sc_hd__decap_12
XFILLER_20_231 VSUBS VSUBS _999_/VPB _999_/VPB sky130_fd_sc_hd__decap_12
XFILLER_47_117 VSUBS VSUBS _999_/VPB _999_/VPB sky130_fd_sc_hd__decap_3
XFILLER_43_301 VSUBS VSUBS _999_/VPB _999_/VPB sky130_fd_sc_hd__decap_6
X_680_ _925_/Q _690_/B VSUBS VSUBS _999_/VPB _999_/VPB _680_/Y sky130_fd_sc_hd__nand2b_1
XFILLER_18_31 VSUBS VSUBS _999_/VPB _999_/VPB sky130_fd_sc_hd__decap_12
XFILLER_28_331 VSUBS VSUBS _999_/VPB _999_/VPB sky130_fd_sc_hd__decap_4
X_947_ _959_/CLK _954_/Q _461_/X VSUBS VSUBS _999_/VPB _999_/VPB _947_/Q sky130_fd_sc_hd__edfxtp_1
X_878_ _969_/CLK _878_/D VSUBS VSUBS _999_/VPB _999_/VPB _878_/Q sky130_fd_sc_hd__dfxtp_1
XFILLER_19_320 VSUBS VSUBS _999_/VPB _999_/VPB sky130_fd_sc_hd__decap_4
XFILLER_61_175 VSUBS VSUBS _999_/VPB _999_/VPB sky130_fd_sc_hd__decap_4
XFILLER_53_109 VSUBS VSUBS _999_/VPB _999_/VPB sky130_fd_sc_hd__decap_8
XFILLER_34_367 VSUBS VSUBS _999_/VPB _999_/VPB sky130_fd_sc_hd__fill_2
XFILLER_25_301 VSUBS VSUBS _999_/VPB _999_/VPB sky130_fd_sc_hd__decap_12
XFILLER_29_117 VSUBS VSUBS _999_/VPB _999_/VPB sky130_fd_sc_hd__decap_3
XTAP_TAPCELL_ROW_50_310 VSUBS _999_/VPB sky130_fd_sc_hd__tapvpwrvgnd_1
XFILLER_4_238 VSUBS VSUBS _999_/VPB _999_/VPB sky130_fd_sc_hd__decap_12
XFILLER_20_43 VSUBS VSUBS _999_/VPB _999_/VPB sky130_fd_sc_hd__decap_12
X_732_ _931_/Q _948_/Q VSUBS VSUBS _999_/VPB _999_/VPB _737_/A sky130_fd_sc_hd__xor2_1
X_801_ _828_/A _801_/B VSUBS VSUBS _999_/VPB _999_/VPB _943_/D sky130_fd_sc_hd__nor2_1
XFILLER_20_87 VSUBS VSUBS _999_/VPB _999_/VPB sky130_fd_sc_hd__decap_3
XFILLER_29_85 VSUBS VSUBS _999_/VPB _999_/VPB sky130_fd_sc_hd__decap_12
X_663_ _945_/Q _662_/Y _459_/B VSUBS VSUBS _999_/VPB _999_/VPB _663_/Y sky130_fd_sc_hd__o21ai_0
XFILLER_45_73 VSUBS VSUBS _999_/VPB _999_/VPB sky130_fd_sc_hd__decap_12
X_594_ _935_/Q _915_/Q VSUBS VSUBS _999_/VPB _999_/VPB _596_/A sky130_fd_sc_hd__xnor2_1
XFILLER_35_109 VSUBS VSUBS _999_/VPB _999_/VPB sky130_fd_sc_hd__decap_8
XFILLER_61_61 VSUBS VSUBS _999_/VPB _999_/VPB sky130_fd_sc_hd__decap_12
XFILLER_31_337 VSUBS VSUBS _999_/VPB _999_/VPB sky130_fd_sc_hd__decap_12
XFILLER_6_12 VSUBS VSUBS _999_/VPB _999_/VPB sky130_fd_sc_hd__decap_12
XFILLER_6_67 VSUBS VSUBS _999_/VPB _999_/VPB sky130_fd_sc_hd__decap_12
XFILLER_34_175 VSUBS VSUBS _999_/VPB _999_/VPB sky130_fd_sc_hd__decap_12
XTAP_TAPCELL_ROW_15_98 VSUBS _999_/VPB sky130_fd_sc_hd__tapvpwrvgnd_1
XFILLER_57_278 VSUBS VSUBS _999_/VPB _999_/VPB sky130_fd_sc_hd__decap_4
XFILLER_17_109 VSUBS VSUBS _999_/VPB _999_/VPB sky130_fd_sc_hd__decap_8
XFILLER_13_337 VSUBS VSUBS _999_/VPB _999_/VPB sky130_fd_sc_hd__fill_2
XFILLER_31_97 VSUBS VSUBS _999_/VPB _999_/VPB sky130_fd_sc_hd__decap_12
X_715_ _723_/A _715_/B VSUBS VSUBS _999_/VPB _999_/VPB _923_/D sky130_fd_sc_hd__nor2_1
XFILLER_48_234 VSUBS VSUBS _999_/VPB _999_/VPB sky130_fd_sc_hd__decap_12
XFILLER_0_241 VSUBS VSUBS _999_/VPB _999_/VPB sky130_fd_sc_hd__decap_12
XTAP_TAPCELL_ROW_18_115 VSUBS _999_/VPB sky130_fd_sc_hd__tapvpwrvgnd_1
X_646_ LAST_CMD[2] _659_/B VSUBS VSUBS _999_/VPB _999_/VPB _648_/A sky130_fd_sc_hd__nor2_1
XFILLER_31_145 VSUBS VSUBS _999_/VPB _999_/VPB sky130_fd_sc_hd__decap_12
X_577_ _559_/B _567_/Y _576_/Y _575_/Y VSUBS VSUBS _999_/VPB _999_/VPB _884_/D sky130_fd_sc_hd__a31oi_1
XFILLER_16_131 VSUBS VSUBS _999_/VPB _999_/VPB sky130_fd_sc_hd__fill_1
XFILLER_16_175 VSUBS VSUBS _999_/VPB _999_/VPB sky130_fd_sc_hd__decap_12
XFILLER_31_189 VSUBS VSUBS _999_/VPB _999_/VPB sky130_fd_sc_hd__fill_2
XFILLER_54_259 VSUBS VSUBS _999_/VPB _999_/VPB sky130_fd_sc_hd__decap_8
XFILLER_11_0 VSUBS VSUBS _999_/VPB _999_/VPB sky130_fd_sc_hd__decap_12
XFILLER_22_189 VSUBS VSUBS _999_/VPB _999_/VPB sky130_fd_sc_hd__fill_2
X_500_ _981_/Q _516_/A _538_/B _500_/D VSUBS VSUBS _999_/VPB _999_/VPB _503_/A sky130_fd_sc_hd__nand4_1
XFILLER_60_207 VSUBS VSUBS _999_/VPB _999_/VPB sky130_fd_sc_hd__decap_3
XFILLER_45_237 VSUBS VSUBS _999_/VPB _999_/VPB sky130_fd_sc_hd__decap_3
Xclkbuf_3_6__f_clk clkbuf_0_clk/X VSUBS VSUBS _999_/VPB _999_/VPB _978_/CLK sky130_fd_sc_hd__clkbuf_16
XFILLER_13_145 VSUBS VSUBS _999_/VPB _999_/VPB sky130_fd_sc_hd__decap_12
XFILLER_26_31 VSUBS VSUBS _999_/VPB _999_/VPB sky130_fd_sc_hd__decap_12
XFILLER_5_355 VSUBS VSUBS _999_/VPB _999_/VPB sky130_fd_sc_hd__decap_4
XFILLER_3_46 VSUBS VSUBS _999_/VPB _999_/VPB sky130_fd_sc_hd__decap_12
XFILLER_51_207 VSUBS VSUBS _999_/VPB _999_/VPB sky130_fd_sc_hd__decap_4
XFILLER_36_259 VSUBS VSUBS _999_/VPB _999_/VPB sky130_fd_sc_hd__decap_8
X_629_ _639_/C VSUBS VSUBS _999_/VPB _999_/VPB _629_/Y sky130_fd_sc_hd__clkinv_1
XTAP_TAPCELL_ROW_46_287 VSUBS _999_/VPB sky130_fd_sc_hd__tapvpwrvgnd_1
XFILLER_59_0 VSUBS VSUBS _999_/VPB _999_/VPB sky130_fd_sc_hd__decap_12
XFILLER_42_207 VSUBS VSUBS _999_/VPB _999_/VPB sky130_fd_sc_hd__decap_3
XTAP_TAPCELL_ROW_37_232 VSUBS _999_/VPB sky130_fd_sc_hd__tapvpwrvgnd_1
XFILLER_10_115 VSUBS VSUBS _999_/VPB _999_/VPB sky130_fd_sc_hd__decap_12
XFILLER_12_55 VSUBS VSUBS _999_/VPB _999_/VPB sky130_fd_sc_hd__decap_12
X_980_ _982_/CLK _980_/D VSUBS VSUBS _999_/VPB _999_/VPB _980_/Q sky130_fd_sc_hd__dfxtp_1
XFILLER_2_358 VSUBS VSUBS _999_/VPB _999_/VPB sky130_fd_sc_hd__decap_8
XFILLER_2_325 VSUBS VSUBS _999_/VPB _999_/VPB sky130_fd_sc_hd__decap_4
XFILLER_37_85 VSUBS VSUBS _999_/VPB _999_/VPB sky130_fd_sc_hd__decap_12
XTAP_TAPCELL_ROW_8_56 VSUBS _999_/VPB sky130_fd_sc_hd__tapvpwrvgnd_1
XFILLER_18_237 VSUBS VSUBS _999_/VPB _999_/VPB sky130_fd_sc_hd__fill_1
XFILLER_53_73 VSUBS VSUBS _999_/VPB _999_/VPB sky130_fd_sc_hd__decap_12
XTAP_TAPCELL_ROW_43_268 VSUBS _999_/VPB sky130_fd_sc_hd__tapvpwrvgnd_1
XTAP_TAPCELL_ROW_34_213 VSUBS _999_/VPB sky130_fd_sc_hd__tapvpwrvgnd_1
XFILLER_32_251 VSUBS VSUBS _999_/VPB _999_/VPB sky130_fd_sc_hd__decap_12
XTAP_TAPCELL_ROW_57_349 VSUBS _999_/VPB sky130_fd_sc_hd__tapvpwrvgnd_1
XTAP_TAPCELL_ROW_40_249 VSUBS _999_/VPB sky130_fd_sc_hd__tapvpwrvgnd_1
XFILLER_23_273 VSUBS VSUBS _999_/VPB _999_/VPB sky130_fd_sc_hd__decap_3
XFILLER_2_199 VSUBS VSUBS _999_/VPB _999_/VPB sky130_fd_sc_hd__decap_8
X_894_ _983_/CLK _894_/D VSUBS VSUBS _999_/VPB _999_/VPB _894_/Q sky130_fd_sc_hd__dfxtp_1
X_963_ _970_/CLK _963_/D VSUBS VSUBS _999_/VPB _999_/VPB _963_/Q sky130_fd_sc_hd__dfxtp_1
XFILLER_61_313 VSUBS VSUBS _999_/VPB _999_/VPB sky130_fd_sc_hd__decap_12
XFILLER_9_12 VSUBS VSUBS _999_/VPB _999_/VPB sky130_fd_sc_hd__decap_12
XFILLER_37_310 VSUBS VSUBS _999_/VPB _999_/VPB sky130_fd_sc_hd__decap_12
XFILLER_52_346 VSUBS VSUBS _999_/VPB _999_/VPB sky130_fd_sc_hd__decap_12
XFILLER_20_243 VSUBS VSUBS _999_/VPB _999_/VPB sky130_fd_sc_hd__decap_12
XFILLER_20_287 VSUBS VSUBS _999_/VPB _999_/VPB sky130_fd_sc_hd__fill_1
XFILLER_34_31 VSUBS VSUBS _999_/VPB _999_/VPB sky130_fd_sc_hd__decap_12
XFILLER_18_43 VSUBS VSUBS _999_/VPB _999_/VPB sky130_fd_sc_hd__decap_12
XFILLER_18_87 VSUBS VSUBS _999_/VPB _999_/VPB sky130_fd_sc_hd__decap_3
XFILLER_28_310 VSUBS VSUBS _999_/VPB _999_/VPB sky130_fd_sc_hd__decap_12
XFILLER_11_254 VSUBS VSUBS _999_/VPB _999_/VPB sky130_fd_sc_hd__decap_12
XFILLER_59_61 VSUBS VSUBS _999_/VPB _999_/VPB sky130_fd_sc_hd__decap_12
X_946_ _959_/CLK _953_/Q _461_/X VSUBS VSUBS _999_/VPB _999_/VPB _946_/Q sky130_fd_sc_hd__edfxtp_1
XFILLER_46_151 VSUBS VSUBS _999_/VPB _999_/VPB sky130_fd_sc_hd__decap_12
X_877_ _969_/CLK _877_/D VSUBS VSUBS _999_/VPB _999_/VPB _877_/Q sky130_fd_sc_hd__dfxtp_1
XFILLER_61_121 VSUBS VSUBS _999_/VPB _999_/VPB sky130_fd_sc_hd__decap_12
XFILLER_41_0 VSUBS VSUBS _999_/VPB _999_/VPB sky130_fd_sc_hd__decap_12
XFILLER_37_162 VSUBS VSUBS _999_/VPB _999_/VPB sky130_fd_sc_hd__decap_12
XFILLER_25_357 VSUBS VSUBS _999_/VPB _999_/VPB sky130_fd_sc_hd__decap_3
XFILLER_29_129 VSUBS VSUBS _999_/VPB _999_/VPB sky130_fd_sc_hd__decap_3
XTAP_TAPCELL_ROW_50_311 VSUBS _999_/VPB sky130_fd_sc_hd__tapvpwrvgnd_1
XFILLER_40_327 VSUBS VSUBS _999_/VPB _999_/VPB sky130_fd_sc_hd__decap_3
XFILLER_20_55 VSUBS VSUBS _999_/VPB _999_/VPB sky130_fd_sc_hd__decap_12
X_731_ _759_/S _729_/Y _730_/Y VSUBS VSUBS _999_/VPB _999_/VPB _928_/D sky130_fd_sc_hd__a21oi_1
X_662_ _978_/Q _980_/Q _523_/B _603_/Y VSUBS VSUBS _999_/VPB _999_/VPB _662_/Y sky130_fd_sc_hd__o211ai_1
X_800_ _943_/Q _788_/A _765_/Y _793_/Y VSUBS VSUBS _999_/VPB _999_/VPB _801_/B sky130_fd_sc_hd__a22oi_1
XFILLER_29_97 VSUBS VSUBS _999_/VPB _999_/VPB sky130_fd_sc_hd__decap_12
X_593_ _933_/Q _442_/Y _592_/Y VSUBS VSUBS _999_/VPB _999_/VPB _599_/A sky130_fd_sc_hd__o21ai_0
XFILLER_45_85 VSUBS VSUBS _999_/VPB _999_/VPB sky130_fd_sc_hd__decap_12
XFILLER_43_121 VSUBS VSUBS _999_/VPB _999_/VPB sky130_fd_sc_hd__decap_12
XFILLER_43_110 VSUBS VSUBS _999_/VPB _999_/VPB sky130_fd_sc_hd__decap_8
XFILLER_31_349 VSUBS VSUBS _999_/VPB _999_/VPB sky130_fd_sc_hd__decap_8
XFILLER_61_73 VSUBS VSUBS _999_/VPB _999_/VPB sky130_fd_sc_hd__decap_12
XFILLER_6_24 VSUBS VSUBS _999_/VPB _999_/VPB sky130_fd_sc_hd__decap_6
XFILLER_6_79 VSUBS VSUBS _999_/VPB _999_/VPB sky130_fd_sc_hd__decap_8
X_929_ _933_/CLK _929_/D VSUBS VSUBS _999_/VPB _999_/VPB _929_/Q sky130_fd_sc_hd__dfxtp_1
XFILLER_19_151 VSUBS VSUBS _999_/VPB _999_/VPB sky130_fd_sc_hd__decap_12
XFILLER_19_184 VSUBS VSUBS _999_/VPB _999_/VPB sky130_fd_sc_hd__decap_8
XFILLER_34_198 VSUBS VSUBS _999_/VPB _999_/VPB sky130_fd_sc_hd__decap_8
XFILLER_34_187 VSUBS VSUBS _999_/VPB _999_/VPB sky130_fd_sc_hd__decap_6
XFILLER_22_349 VSUBS VSUBS _999_/VPB _999_/VPB sky130_fd_sc_hd__fill_1
XTAP_TAPCELL_ROW_15_99 VSUBS _999_/VPB sky130_fd_sc_hd__tapvpwrvgnd_1
XFILLER_25_121 VSUBS VSUBS _999_/VPB _999_/VPB sky130_fd_sc_hd__decap_12
XFILLER_9_309 VSUBS VSUBS _999_/VPB _999_/VPB sky130_fd_sc_hd__decap_3
XFILLER_0_253 VSUBS VSUBS _999_/VPB _999_/VPB sky130_fd_sc_hd__decap_12
X_714_ _923_/Q _948_/Q _722_/S VSUBS VSUBS _999_/VPB _999_/VPB _715_/B sky130_fd_sc_hd__mux2i_1
X_645_ _645_/A _645_/B VSUBS VSUBS _999_/VPB _999_/VPB _901_/D sky130_fd_sc_hd__nor2_1
XFILLER_48_246 VSUBS VSUBS _999_/VPB _999_/VPB sky130_fd_sc_hd__decap_6
XTAP_TAPCELL_ROW_18_116 VSUBS _999_/VPB sky130_fd_sc_hd__tapvpwrvgnd_1
XFILLER_31_179 VSUBS VSUBS _999_/VPB _999_/VPB sky130_fd_sc_hd__fill_1
XFILLER_31_157 VSUBS VSUBS _999_/VPB _999_/VPB sky130_fd_sc_hd__decap_8
X_576_ _939_/Q _765_/B VSUBS VSUBS _999_/VPB _999_/VPB _576_/Y sky130_fd_sc_hd__nand2_1
XFILLER_16_187 VSUBS VSUBS _999_/VPB _999_/VPB sky130_fd_sc_hd__decap_3
XFILLER_8_331 VSUBS VSUBS _999_/VPB _999_/VPB sky130_fd_sc_hd__decap_12
XFILLER_22_157 VSUBS VSUBS _999_/VPB _999_/VPB sky130_fd_sc_hd__fill_2
XFILLER_45_205 VSUBS VSUBS _999_/VPB _999_/VPB sky130_fd_sc_hd__decap_12
XFILLER_42_31 VSUBS VSUBS _999_/VPB _999_/VPB sky130_fd_sc_hd__decap_12
XFILLER_9_117 VSUBS VSUBS _999_/VPB _999_/VPB sky130_fd_sc_hd__decap_3
XFILLER_13_157 VSUBS VSUBS _999_/VPB _999_/VPB sky130_fd_sc_hd__decap_12
XFILLER_26_43 VSUBS VSUBS _999_/VPB _999_/VPB sky130_fd_sc_hd__decap_12
XFILLER_26_87 VSUBS VSUBS _999_/VPB _999_/VPB sky130_fd_sc_hd__decap_3
XFILLER_5_301 VSUBS VSUBS _999_/VPB _999_/VPB sky130_fd_sc_hd__decap_4
XFILLER_3_58 VSUBS VSUBS _999_/VPB _999_/VPB sky130_fd_sc_hd__fill_2
X_628_ _976_/Q _977_/Q _627_/B _627_/Y _518_/B VSUBS VSUBS _999_/VPB _999_/VPB _639_/C
+ sky130_fd_sc_hd__o311ai_0
XFILLER_44_293 VSUBS VSUBS _999_/VPB _999_/VPB sky130_fd_sc_hd__decap_12
X_559_ _559_/A _559_/B VSUBS VSUBS _999_/VPB _999_/VPB _879_/D sky130_fd_sc_hd__nor2_1
XTAP_TAPCELL_ROW_12_78 VSUBS _999_/VPB sky130_fd_sc_hd__tapvpwrvgnd_1
XFILLER_27_205 VSUBS VSUBS _999_/VPB _999_/VPB sky130_fd_sc_hd__decap_12
XFILLER_42_219 VSUBS VSUBS _999_/VPB _999_/VPB sky130_fd_sc_hd__fill_2
XTAP_TAPCELL_ROW_37_233 VSUBS _999_/VPB sky130_fd_sc_hd__tapvpwrvgnd_1
XFILLER_10_127 VSUBS VSUBS _999_/VPB _999_/VPB sky130_fd_sc_hd__decap_12
XFILLER_12_12 VSUBS VSUBS _999_/VPB _999_/VPB sky130_fd_sc_hd__decap_12
XFILLER_12_67 VSUBS VSUBS _999_/VPB _999_/VPB sky130_fd_sc_hd__decap_12
XFILLER_37_97 VSUBS VSUBS _999_/VPB _999_/VPB sky130_fd_sc_hd__decap_12
XTAP_TAPCELL_ROW_8_57 VSUBS _999_/VPB sky130_fd_sc_hd__tapvpwrvgnd_1
XFILLER_26_271 VSUBS VSUBS _999_/VPB _999_/VPB sky130_fd_sc_hd__decap_8
XFILLER_53_85 VSUBS VSUBS _999_/VPB _999_/VPB sky130_fd_sc_hd__decap_12
XTAP_TAPCELL_ROW_43_269 VSUBS _999_/VPB sky130_fd_sc_hd__tapvpwrvgnd_1
XFILLER_41_241 VSUBS VSUBS _999_/VPB _999_/VPB sky130_fd_sc_hd__decap_12
XTAP_TAPCELL_ROW_34_214 VSUBS _999_/VPB sky130_fd_sc_hd__tapvpwrvgnd_1
XFILLER_32_263 VSUBS VSUBS _999_/VPB _999_/VPB sky130_fd_sc_hd__decap_6
XFILLER_32_285 VSUBS VSUBS _999_/VPB _999_/VPB sky130_fd_sc_hd__decap_4
XFILLER_23_22 VSUBS VSUBS _999_/VPB _999_/VPB sky130_fd_sc_hd__decap_12
XFILLER_23_241 VSUBS VSUBS _999_/VPB _999_/VPB sky130_fd_sc_hd__decap_12
X_962_ _982_/CLK _962_/D VSUBS VSUBS _999_/VPB _999_/VPB _962_/Q sky130_fd_sc_hd__dfxtp_1
X_893_ _983_/CLK _893_/D VSUBS VSUBS _999_/VPB _999_/VPB _893_/Q sky130_fd_sc_hd__dfxtp_1
XFILLER_61_325 VSUBS VSUBS _999_/VPB _999_/VPB sky130_fd_sc_hd__decap_4
XFILLER_46_366 VSUBS VSUBS _999_/VPB _999_/VPB sky130_fd_sc_hd__decap_3
XFILLER_0_59 VSUBS VSUBS _999_/VPB _999_/VPB sky130_fd_sc_hd__fill_1
XFILLER_9_24 VSUBS VSUBS _999_/VPB _999_/VPB sky130_fd_sc_hd__decap_12
XFILLER_14_285 VSUBS VSUBS _999_/VPB _999_/VPB sky130_fd_sc_hd__fill_2
XFILLER_37_322 VSUBS VSUBS _999_/VPB _999_/VPB sky130_fd_sc_hd__decap_12
XFILLER_52_358 VSUBS VSUBS _999_/VPB _999_/VPB sky130_fd_sc_hd__decap_8
XFILLER_20_255 VSUBS VSUBS _999_/VPB _999_/VPB sky130_fd_sc_hd__decap_12
XFILLER_28_322 VSUBS VSUBS _999_/VPB _999_/VPB sky130_fd_sc_hd__decap_8
XFILLER_34_43 VSUBS VSUBS _999_/VPB _999_/VPB sky130_fd_sc_hd__decap_12
XFILLER_18_55 VSUBS VSUBS _999_/VPB _999_/VPB sky130_fd_sc_hd__decap_12
XFILLER_28_366 VSUBS VSUBS _999_/VPB _999_/VPB sky130_fd_sc_hd__decap_3
XFILLER_50_31 VSUBS VSUBS _999_/VPB _999_/VPB sky130_fd_sc_hd__decap_12
XFILLER_34_87 VSUBS VSUBS _999_/VPB _999_/VPB sky130_fd_sc_hd__decap_3
XTAP_TAPCELL_ROW_5_36 VSUBS _999_/VPB sky130_fd_sc_hd__tapvpwrvgnd_1
XFILLER_11_211 VSUBS VSUBS _999_/VPB _999_/VPB sky130_fd_sc_hd__decap_6
XFILLER_11_266 VSUBS VSUBS _999_/VPB _999_/VPB sky130_fd_sc_hd__fill_1
XFILLER_11_299 VSUBS VSUBS _999_/VPB _999_/VPB sky130_fd_sc_hd__fill_1
XFILLER_59_73 VSUBS VSUBS _999_/VPB _999_/VPB sky130_fd_sc_hd__decap_12
X_945_ _959_/CLK ESPI_IO0_IN _461_/X VSUBS VSUBS _999_/VPB _999_/VPB _945_/Q sky130_fd_sc_hd__edfxtp_1
XFILLER_1_0 VSUBS VSUBS _999_/VPB _999_/VPB sky130_fd_sc_hd__decap_12
XFILLER_46_163 VSUBS VSUBS _999_/VPB _999_/VPB sky130_fd_sc_hd__decap_8
X_876_ _969_/CLK _876_/D VSUBS VSUBS _999_/VPB _999_/VPB _876_/Q sky130_fd_sc_hd__dfxtp_1
XFILLER_61_133 VSUBS VSUBS _999_/VPB _999_/VPB sky130_fd_sc_hd__decap_12
XFILLER_34_0 VSUBS VSUBS _999_/VPB _999_/VPB sky130_fd_sc_hd__decap_12
XFILLER_52_133 VSUBS VSUBS _999_/VPB _999_/VPB sky130_fd_sc_hd__fill_1
XFILLER_37_174 VSUBS VSUBS _999_/VPB _999_/VPB sky130_fd_sc_hd__decap_6
XFILLER_25_347 VSUBS VSUBS _999_/VPB _999_/VPB sky130_fd_sc_hd__fill_1
XFILLER_4_207 VSUBS VSUBS _999_/VPB _999_/VPB sky130_fd_sc_hd__decap_3
XFILLER_20_12 VSUBS VSUBS _999_/VPB _999_/VPB sky130_fd_sc_hd__decap_12
XFILLER_20_67 VSUBS VSUBS _999_/VPB _999_/VPB sky130_fd_sc_hd__decap_12
X_592_ _932_/Q _443_/Y _910_/Q _436_/Y _446_/Y _929_/Q VSUBS VSUBS _999_/VPB _999_/VPB
+ _592_/Y sky130_fd_sc_hd__a222oi_1
X_730_ _928_/Q _759_/S _873_/B VSUBS VSUBS _999_/VPB _999_/VPB _730_/Y sky130_fd_sc_hd__o21ai_0
X_661_ _661_/A _661_/B VSUBS VSUBS _999_/VPB _999_/VPB _907_/D sky130_fd_sc_hd__nor2_1
XFILLER_45_97 VSUBS VSUBS _999_/VPB _999_/VPB sky130_fd_sc_hd__decap_12
XFILLER_43_155 VSUBS VSUBS _999_/VPB _999_/VPB sky130_fd_sc_hd__decap_12
XFILLER_43_133 VSUBS VSUBS _999_/VPB _999_/VPB sky130_fd_sc_hd__fill_1
XFILLER_61_85 VSUBS VSUBS _999_/VPB _999_/VPB sky130_fd_sc_hd__decap_4
X_928_ _933_/CLK _928_/D VSUBS VSUBS _999_/VPB _999_/VPB _928_/Q sky130_fd_sc_hd__dfxtp_1
X_859_ _971_/Q _859_/B _870_/C VSUBS VSUBS _999_/VPB _999_/VPB _863_/B sky130_fd_sc_hd__nor3_1
XFILLER_19_141 VSUBS VSUBS _999_/VPB _999_/VPB sky130_fd_sc_hd__fill_2
XFILLER_19_163 VSUBS VSUBS _999_/VPB _999_/VPB sky130_fd_sc_hd__decap_12
XFILLER_19_196 VSUBS VSUBS _999_/VPB _999_/VPB sky130_fd_sc_hd__decap_12
XTAP_TAPCELL_ROW_29_180 VSUBS _999_/VPB sky130_fd_sc_hd__tapvpwrvgnd_1
XFILLER_40_147 VSUBS VSUBS _999_/VPB _999_/VPB sky130_fd_sc_hd__decap_3
XFILLER_40_103 VSUBS VSUBS _999_/VPB _999_/VPB sky130_fd_sc_hd__decap_12
XFILLER_13_317 VSUBS VSUBS _999_/VPB _999_/VPB sky130_fd_sc_hd__decap_12
XFILLER_15_12 VSUBS VSUBS _999_/VPB _999_/VPB sky130_fd_sc_hd__decap_12
XFILLER_25_133 VSUBS VSUBS _999_/VPB _999_/VPB sky130_fd_sc_hd__decap_12
XFILLER_25_177 VSUBS VSUBS _999_/VPB _999_/VPB sky130_fd_sc_hd__decap_3
XFILLER_21_361 VSUBS VSUBS _999_/VPB _999_/VPB sky130_fd_sc_hd__decap_8
XFILLER_0_265 VSUBS VSUBS _999_/VPB _999_/VPB sky130_fd_sc_hd__decap_4
X_713_ _723_/A _713_/B VSUBS VSUBS _999_/VPB _999_/VPB _922_/D sky130_fd_sc_hd__nor2_1
XFILLER_48_269 VSUBS VSUBS _999_/VPB _999_/VPB sky130_fd_sc_hd__fill_1
X_644_ _946_/Q _526_/C _459_/B VSUBS VSUBS _999_/VPB _999_/VPB _645_/B sky130_fd_sc_hd__o21ai_0
X_575_ _884_/Q _562_/X _587_/C VSUBS VSUBS _999_/VPB _999_/VPB _575_/Y sky130_fd_sc_hd__o21ai_0
XTAP_TAPCELL_ROW_18_117 VSUBS _999_/VPB sky130_fd_sc_hd__tapvpwrvgnd_1
XFILLER_8_343 VSUBS VSUBS _999_/VPB _999_/VPB sky130_fd_sc_hd__fill_2
XFILLER_39_225 VSUBS VSUBS _999_/VPB _999_/VPB sky130_fd_sc_hd__fill_1
XFILLER_22_103 VSUBS VSUBS _999_/VPB _999_/VPB sky130_fd_sc_hd__decap_12
XFILLER_22_147 VSUBS VSUBS _999_/VPB _999_/VPB sky130_fd_sc_hd__decap_3
XFILLER_45_217 VSUBS VSUBS _999_/VPB _999_/VPB sky130_fd_sc_hd__decap_12
XFILLER_38_291 VSUBS VSUBS _999_/VPB _999_/VPB sky130_fd_sc_hd__decap_4
XFILLER_26_55 VSUBS VSUBS _999_/VPB _999_/VPB sky130_fd_sc_hd__decap_12
XFILLER_53_294 VSUBS VSUBS _999_/VPB _999_/VPB sky130_fd_sc_hd__fill_1
XFILLER_42_87 VSUBS VSUBS _999_/VPB _999_/VPB sky130_fd_sc_hd__decap_3
XFILLER_42_43 VSUBS VSUBS _999_/VPB _999_/VPB sky130_fd_sc_hd__decap_12
XFILLER_13_169 VSUBS VSUBS _999_/VPB _999_/VPB sky130_fd_sc_hd__decap_8
X_627_ _975_/Q _627_/B VSUBS VSUBS _999_/VPB _999_/VPB _627_/Y sky130_fd_sc_hd__nand2_1
X_558_ _538_/A _979_/Q _538_/B _554_/A _557_/Y VSUBS VSUBS _999_/VPB _999_/VPB _559_/B
+ sky130_fd_sc_hd__a32oi_1
Xspare_inverter_0 spare_inverter_0/A VSUBS VSUBS _999_/VPB _999_/VPB spare_inverter_0/Y
+ sky130_fd_sc_hd__inv_1
XFILLER_8_151 VSUBS VSUBS _999_/VPB _999_/VPB sky130_fd_sc_hd__decap_12
X_489_ _975_/Q _981_/Q _873_/B VSUBS VSUBS _999_/VPB _999_/VPB _489_/Y sky130_fd_sc_hd__nand3_1
XTAP_TAPCELL_ROW_12_79 VSUBS _999_/VPB sky130_fd_sc_hd__tapvpwrvgnd_1
XFILLER_27_217 VSUBS VSUBS _999_/VPB _999_/VPB sky130_fd_sc_hd__decap_6
XFILLER_50_242 VSUBS VSUBS _999_/VPB _999_/VPB sky130_fd_sc_hd__fill_1
XFILLER_10_139 VSUBS VSUBS _999_/VPB _999_/VPB sky130_fd_sc_hd__decap_8
XFILLER_12_24 VSUBS VSUBS _999_/VPB _999_/VPB sky130_fd_sc_hd__decap_6
XFILLER_12_79 VSUBS VSUBS _999_/VPB _999_/VPB sky130_fd_sc_hd__decap_8
XFILLER_18_206 VSUBS VSUBS _999_/VPB _999_/VPB sky130_fd_sc_hd__decap_4
XFILLER_33_209 VSUBS VSUBS _999_/VPB _999_/VPB sky130_fd_sc_hd__decap_8
XTAP_TAPCELL_ROW_8_58 VSUBS _999_/VPB sky130_fd_sc_hd__tapvpwrvgnd_1
XFILLER_18_217 VSUBS VSUBS _999_/VPB _999_/VPB sky130_fd_sc_hd__fill_1
XFILLER_53_97 VSUBS VSUBS _999_/VPB _999_/VPB sky130_fd_sc_hd__decap_12
XFILLER_41_253 VSUBS VSUBS _999_/VPB _999_/VPB sky130_fd_sc_hd__decap_12
XFILLER_5_121 VSUBS VSUBS _999_/VPB _999_/VPB sky130_fd_sc_hd__decap_12
XTAP_TAPCELL_ROW_34_215 VSUBS _999_/VPB sky130_fd_sc_hd__tapvpwrvgnd_1
XFILLER_59_117 VSUBS VSUBS _999_/VPB _999_/VPB sky130_fd_sc_hd__decap_3
XFILLER_55_301 VSUBS VSUBS _999_/VPB _999_/VPB sky130_fd_sc_hd__decap_12
XFILLER_4_91 VSUBS VSUBS _999_/VPB _999_/VPB sky130_fd_sc_hd__decap_12
XFILLER_15_209 VSUBS VSUBS _999_/VPB _999_/VPB sky130_fd_sc_hd__decap_12
XFILLER_23_12 VSUBS VSUBS _999_/VPB _999_/VPB sky130_fd_sc_hd__decap_6
XFILLER_23_34 VSUBS VSUBS _999_/VPB _999_/VPB sky130_fd_sc_hd__decap_12
XFILLER_23_253 VSUBS VSUBS _999_/VPB _999_/VPB sky130_fd_sc_hd__decap_12
X_961_ _982_/CLK _961_/D VSUBS VSUBS _999_/VPB _999_/VPB _961_/Q sky130_fd_sc_hd__dfxtp_1
XFILLER_48_31 VSUBS VSUBS _999_/VPB _999_/VPB sky130_fd_sc_hd__decap_12
X_892_ _981_/CLK _892_/D VSUBS VSUBS _999_/VPB _999_/VPB _892_/Q sky130_fd_sc_hd__dfxtp_1
XFILLER_61_359 VSUBS VSUBS _999_/VPB _999_/VPB sky130_fd_sc_hd__fill_1
XFILLER_9_36 VSUBS VSUBS _999_/VPB _999_/VPB sky130_fd_sc_hd__decap_12
XFILLER_37_334 VSUBS VSUBS _999_/VPB _999_/VPB sky130_fd_sc_hd__decap_4
XFILLER_37_301 VSUBS VSUBS _999_/VPB _999_/VPB sky130_fd_sc_hd__decap_6
XFILLER_20_267 VSUBS VSUBS _999_/VPB _999_/VPB sky130_fd_sc_hd__decap_3
XFILLER_47_109 VSUBS VSUBS _999_/VPB _999_/VPB sky130_fd_sc_hd__decap_8
XFILLER_18_12 VSUBS VSUBS _999_/VPB _999_/VPB sky130_fd_sc_hd__decap_12
XFILLER_18_67 VSUBS VSUBS _999_/VPB _999_/VPB sky130_fd_sc_hd__decap_12
XFILLER_55_153 VSUBS VSUBS _999_/VPB _999_/VPB sky130_fd_sc_hd__fill_2
XFILLER_34_55 VSUBS VSUBS _999_/VPB _999_/VPB sky130_fd_sc_hd__decap_12
XTAP_TAPCELL_ROW_5_37 VSUBS _999_/VPB sky130_fd_sc_hd__tapvpwrvgnd_1
XFILLER_50_87 VSUBS VSUBS _999_/VPB _999_/VPB sky130_fd_sc_hd__decap_3
XFILLER_50_43 VSUBS VSUBS _999_/VPB _999_/VPB sky130_fd_sc_hd__decap_12
XFILLER_59_85 VSUBS VSUBS _999_/VPB _999_/VPB sky130_fd_sc_hd__decap_12
X_944_ _982_/CLK _944_/D VSUBS VSUBS _999_/VPB _999_/VPB _944_/Q sky130_fd_sc_hd__dfxtp_1
X_875_ _982_/CLK _875_/D VSUBS VSUBS _999_/VPB _999_/VPB _875_/Q sky130_fd_sc_hd__dfxtp_1
XFILLER_34_359 VSUBS VSUBS _999_/VPB _999_/VPB sky130_fd_sc_hd__decap_8
XFILLER_19_301 VSUBS VSUBS _999_/VPB _999_/VPB sky130_fd_sc_hd__decap_3
XFILLER_19_356 VSUBS VSUBS _999_/VPB _999_/VPB sky130_fd_sc_hd__decap_4
XFILLER_61_145 VSUBS VSUBS _999_/VPB _999_/VPB sky130_fd_sc_hd__decap_4
XFILLER_6_271 VSUBS VSUBS _999_/VPB _999_/VPB sky130_fd_sc_hd__decap_3
XFILLER_27_0 VSUBS VSUBS _999_/VPB _999_/VPB sky130_fd_sc_hd__decap_12
XFILLER_29_109 VSUBS VSUBS _999_/VPB _999_/VPB sky130_fd_sc_hd__decap_8
XFILLER_37_197 VSUBS VSUBS _999_/VPB _999_/VPB sky130_fd_sc_hd__fill_1
XFILLER_20_24 VSUBS VSUBS _999_/VPB _999_/VPB sky130_fd_sc_hd__decap_6
XFILLER_20_79 VSUBS VSUBS _999_/VPB _999_/VPB sky130_fd_sc_hd__decap_8
X_591_ _932_/Q _443_/Y _442_/Y _933_/Q VSUBS VSUBS _999_/VPB _999_/VPB _591_/Y sky130_fd_sc_hd__a2bb2oi_1
X_660_ _952_/Q _526_/C _459_/B VSUBS VSUBS _999_/VPB _999_/VPB _661_/B sky130_fd_sc_hd__o21ai_0
XFILLER_61_31 VSUBS VSUBS _999_/VPB _999_/VPB sky130_fd_sc_hd__decap_12
XFILLER_43_167 VSUBS VSUBS _999_/VPB _999_/VPB sky130_fd_sc_hd__decap_6
X_927_ _978_/CLK _927_/D VSUBS VSUBS _999_/VPB _999_/VPB _927_/Q sky130_fd_sc_hd__dfxtp_1
X_858_ _974_/Q _973_/Q _972_/Q VSUBS VSUBS _999_/VPB _999_/VPB _870_/C sky130_fd_sc_hd__nor3_1
XFILLER_34_145 VSUBS VSUBS _999_/VPB _999_/VPB sky130_fd_sc_hd__decap_4
X_789_ _940_/Q _787_/Y _873_/B VSUBS VSUBS _999_/VPB _999_/VPB _790_/B sky130_fd_sc_hd__o21ai_0
XFILLER_19_175 VSUBS VSUBS _999_/VPB _999_/VPB sky130_fd_sc_hd__decap_4
XFILLER_22_329 VSUBS VSUBS _999_/VPB _999_/VPB sky130_fd_sc_hd__fill_1
XTAP_TAPCELL_ROW_29_181 VSUBS _999_/VPB sky130_fd_sc_hd__tapvpwrvgnd_1
XFILLER_57_248 VSUBS VSUBS _999_/VPB _999_/VPB sky130_fd_sc_hd__decap_6
XFILLER_40_115 VSUBS VSUBS _999_/VPB _999_/VPB sky130_fd_sc_hd__decap_12
XFILLER_13_329 VSUBS VSUBS _999_/VPB _999_/VPB sky130_fd_sc_hd__decap_8
XFILLER_15_24 VSUBS VSUBS _999_/VPB _999_/VPB sky130_fd_sc_hd__decap_12
XFILLER_25_145 VSUBS VSUBS _999_/VPB _999_/VPB sky130_fd_sc_hd__decap_12
XFILLER_31_12 VSUBS VSUBS _999_/VPB _999_/VPB sky130_fd_sc_hd__decap_12
XFILLER_56_31 VSUBS VSUBS _999_/VPB _999_/VPB sky130_fd_sc_hd__decap_12
X_712_ _922_/Q _947_/Q _722_/S VSUBS VSUBS _999_/VPB _999_/VPB _713_/B sky130_fd_sc_hd__mux2i_1
XFILLER_0_211 VSUBS VSUBS _999_/VPB _999_/VPB sky130_fd_sc_hd__decap_12
XFILLER_0_299 VSUBS VSUBS _999_/VPB _999_/VPB sky130_fd_sc_hd__fill_1
X_643_ LAST_CMD[1] _659_/B VSUBS VSUBS _999_/VPB _999_/VPB _645_/A sky130_fd_sc_hd__nor2_1
X_574_ _555_/B _567_/Y _573_/Y _572_/Y VSUBS VSUBS _999_/VPB _999_/VPB _883_/D sky130_fd_sc_hd__a31oi_1
XTAP_TAPCELL_ROW_18_118 VSUBS _999_/VPB sky130_fd_sc_hd__tapvpwrvgnd_1
XTAP_TAPCELL_ROW_26_162 VSUBS _999_/VPB sky130_fd_sc_hd__tapvpwrvgnd_1
XFILLER_39_237 VSUBS VSUBS _999_/VPB _999_/VPB sky130_fd_sc_hd__decap_3
XFILLER_22_115 VSUBS VSUBS _999_/VPB _999_/VPB sky130_fd_sc_hd__decap_12
XTAP_TAPCELL_ROW_32_198 VSUBS _999_/VPB sky130_fd_sc_hd__tapvpwrvgnd_1
XFILLER_45_229 VSUBS VSUBS _999_/VPB _999_/VPB sky130_fd_sc_hd__decap_8
XFILLER_26_12 VSUBS VSUBS _999_/VPB _999_/VPB sky130_fd_sc_hd__decap_12
XFILLER_26_67 VSUBS VSUBS _999_/VPB _999_/VPB sky130_fd_sc_hd__decap_12
XFILLER_42_55 VSUBS VSUBS _999_/VPB _999_/VPB sky130_fd_sc_hd__decap_12
X_626_ _622_/C _624_/Y _625_/Y VSUBS VSUBS _999_/VPB _999_/VPB _895_/D sky130_fd_sc_hd__a21oi_1
X_488_ _981_/Q _516_/A _488_/C VSUBS VSUBS _999_/VPB _999_/VPB _488_/Y sky130_fd_sc_hd__nand3_1
X_557_ _541_/X _556_/Y _540_/Y VSUBS VSUBS _999_/VPB _999_/VPB _557_/Y sky130_fd_sc_hd__o21ai_0
Xspare_inverter_1 spare_inverter_1/A VSUBS VSUBS _999_/VPB _999_/VPB spare_inverter_1/Y
+ sky130_fd_sc_hd__inv_1
XFILLER_8_163 VSUBS VSUBS _999_/VPB _999_/VPB sky130_fd_sc_hd__decap_4
XFILLER_35_284 VSUBS VSUBS _999_/VPB _999_/VPB sky130_fd_sc_hd__decap_12
XFILLER_2_339 VSUBS VSUBS _999_/VPB _999_/VPB sky130_fd_sc_hd__decap_3
XFILLER_41_265 VSUBS VSUBS _999_/VPB _999_/VPB sky130_fd_sc_hd__decap_6
XTAP_TAPCELL_ROW_8_59 VSUBS _999_/VPB sky130_fd_sc_hd__tapvpwrvgnd_1
XFILLER_5_133 VSUBS VSUBS _999_/VPB _999_/VPB sky130_fd_sc_hd__decap_12
XFILLER_5_177 VSUBS VSUBS _999_/VPB _999_/VPB sky130_fd_sc_hd__decap_3
XFILLER_1_361 VSUBS VSUBS _999_/VPB _999_/VPB sky130_fd_sc_hd__decap_8
XTAP_TAPCELL_ROW_59_360 VSUBS _999_/VPB sky130_fd_sc_hd__tapvpwrvgnd_1
XFILLER_17_273 VSUBS VSUBS _999_/VPB _999_/VPB sky130_fd_sc_hd__decap_8
X_609_ _891_/Q _606_/B _892_/Q VSUBS VSUBS _999_/VPB _999_/VPB _609_/Y sky130_fd_sc_hd__o21ai_0
XTAP_TAPCELL_ROW_42_260 VSUBS _999_/VPB sky130_fd_sc_hd__tapvpwrvgnd_1
XFILLER_57_0 VSUBS VSUBS _999_/VPB _999_/VPB sky130_fd_sc_hd__decap_12
XFILLER_55_313 VSUBS VSUBS _999_/VPB _999_/VPB sky130_fd_sc_hd__decap_12
XFILLER_55_357 VSUBS VSUBS _999_/VPB _999_/VPB sky130_fd_sc_hd__decap_3
XFILLER_23_265 VSUBS VSUBS _999_/VPB _999_/VPB sky130_fd_sc_hd__decap_8
XFILLER_23_46 VSUBS VSUBS _999_/VPB _999_/VPB sky130_fd_sc_hd__decap_12
XFILLER_48_43 VSUBS VSUBS _999_/VPB _999_/VPB sky130_fd_sc_hd__decap_12
X_960_ _982_/CLK _960_/D VSUBS VSUBS _999_/VPB _999_/VPB _960_/Q sky130_fd_sc_hd__dfxtp_1
XFILLER_2_147 VSUBS VSUBS _999_/VPB _999_/VPB sky130_fd_sc_hd__decap_3
XFILLER_2_103 VSUBS VSUBS _999_/VPB _999_/VPB sky130_fd_sc_hd__decap_12
X_891_ _981_/CLK _891_/D VSUBS VSUBS _999_/VPB _999_/VPB _891_/Q sky130_fd_sc_hd__dfxtp_1
XFILLER_58_195 VSUBS VSUBS _999_/VPB _999_/VPB sky130_fd_sc_hd__fill_1
XFILLER_48_87 VSUBS VSUBS _999_/VPB _999_/VPB sky130_fd_sc_hd__decap_3
XFILLER_46_335 VSUBS VSUBS _999_/VPB _999_/VPB sky130_fd_sc_hd__fill_1
XFILLER_9_48 VSUBS VSUBS _999_/VPB _999_/VPB sky130_fd_sc_hd__decap_12
XFILLER_37_357 VSUBS VSUBS _999_/VPB _999_/VPB sky130_fd_sc_hd__decap_3
XFILLER_55_121 VSUBS VSUBS _999_/VPB _999_/VPB sky130_fd_sc_hd__decap_12
XFILLER_18_24 VSUBS VSUBS _999_/VPB _999_/VPB sky130_fd_sc_hd__decap_6
XFILLER_18_79 VSUBS VSUBS _999_/VPB _999_/VPB sky130_fd_sc_hd__decap_8
XFILLER_34_67 VSUBS VSUBS _999_/VPB _999_/VPB sky130_fd_sc_hd__decap_12
XFILLER_34_12 VSUBS VSUBS _999_/VPB _999_/VPB sky130_fd_sc_hd__decap_12
XTAP_TAPCELL_ROW_5_38 VSUBS _999_/VPB sky130_fd_sc_hd__tapvpwrvgnd_1
XFILLER_50_55 VSUBS VSUBS _999_/VPB _999_/VPB sky130_fd_sc_hd__decap_12
XFILLER_7_239 VSUBS VSUBS _999_/VPB _999_/VPB sky130_fd_sc_hd__fill_1
Xclkload0 _983_/CLK VSUBS VSUBS _999_/VPB _999_/VPB clkload0/Y sky130_fd_sc_hd__inv_6
XFILLER_59_97 VSUBS VSUBS _999_/VPB _999_/VPB sky130_fd_sc_hd__decap_12
X_874_ _982_/CLK _874_/D VSUBS VSUBS _999_/VPB _999_/VPB _874_/Q sky130_fd_sc_hd__dfxtp_1
X_943_ _969_/CLK _943_/D VSUBS VSUBS _999_/VPB _999_/VPB _943_/Q sky130_fd_sc_hd__dfxtp_1
XFILLER_46_143 VSUBS VSUBS _999_/VPB _999_/VPB sky130_fd_sc_hd__fill_1
XFILLER_61_179 VSUBS VSUBS _999_/VPB _999_/VPB sky130_fd_sc_hd__fill_1
XFILLER_37_121 VSUBS VSUBS _999_/VPB _999_/VPB sky130_fd_sc_hd__decap_12
XFILLER_29_12 VSUBS VSUBS _999_/VPB _999_/VPB sky130_fd_sc_hd__decap_12
X_590_ _928_/Q _908_/Q VSUBS VSUBS _999_/VPB _999_/VPB _597_/B sky130_fd_sc_hd__xnor2_1
XFILLER_61_43 VSUBS VSUBS _999_/VPB _999_/VPB sky130_fd_sc_hd__decap_12
XFILLER_10_91 VSUBS VSUBS _999_/VPB _999_/VPB sky130_fd_sc_hd__decap_12
X_926_ _978_/CLK _926_/D VSUBS VSUBS _999_/VPB _999_/VPB _926_/Q sky130_fd_sc_hd__dfxtp_1
X_788_ _788_/A _788_/B VSUBS VSUBS _999_/VPB _999_/VPB _790_/A sky130_fd_sc_hd__nor2_1
X_857_ _833_/Y _855_/Y _856_/Y VSUBS VSUBS _999_/VPB _999_/VPB _970_/D sky130_fd_sc_hd__a21oi_1
XFILLER_19_121 VSUBS VSUBS _999_/VPB _999_/VPB sky130_fd_sc_hd__decap_12
XTAP_TAPCELL_ROW_29_182 VSUBS _999_/VPB sky130_fd_sc_hd__tapvpwrvgnd_1
XFILLER_57_227 VSUBS VSUBS _999_/VPB _999_/VPB sky130_fd_sc_hd__fill_1
XFILLER_25_157 VSUBS VSUBS _999_/VPB _999_/VPB sky130_fd_sc_hd__decap_12
XFILLER_40_127 VSUBS VSUBS _999_/VPB _999_/VPB sky130_fd_sc_hd__decap_12
XFILLER_31_24 VSUBS VSUBS _999_/VPB _999_/VPB sky130_fd_sc_hd__decap_12
XFILLER_15_36 VSUBS VSUBS _999_/VPB _999_/VPB sky130_fd_sc_hd__decap_12
XFILLER_56_43 VSUBS VSUBS _999_/VPB _999_/VPB sky130_fd_sc_hd__decap_12
X_711_ _723_/A _711_/B VSUBS VSUBS _999_/VPB _999_/VPB _921_/D sky130_fd_sc_hd__nor2_1
XFILLER_0_223 VSUBS VSUBS _999_/VPB _999_/VPB sky130_fd_sc_hd__decap_12
X_642_ _642_/A _642_/B VSUBS VSUBS _999_/VPB _999_/VPB _900_/D sky130_fd_sc_hd__nor2_1
XFILLER_56_87 VSUBS VSUBS _999_/VPB _999_/VPB sky130_fd_sc_hd__decap_3
X_573_ _938_/Q _765_/B VSUBS VSUBS _999_/VPB _999_/VPB _573_/Y sky130_fd_sc_hd__nand2_1
XTAP_TAPCELL_ROW_18_119 VSUBS _999_/VPB sky130_fd_sc_hd__tapvpwrvgnd_1
XTAP_TAPCELL_ROW_26_163 VSUBS _999_/VPB sky130_fd_sc_hd__tapvpwrvgnd_1
Xclkbuf_3_1__f_clk clkbuf_0_clk/X VSUBS VSUBS _999_/VPB _999_/VPB _981_/CLK sky130_fd_sc_hd__clkbuf_16
XFILLER_39_205 VSUBS VSUBS _999_/VPB _999_/VPB sky130_fd_sc_hd__decap_12
X_909_ _933_/CLK _909_/D VSUBS VSUBS _999_/VPB _999_/VPB _909_/Q sky130_fd_sc_hd__dfxtp_1
XFILLER_22_127 VSUBS VSUBS _999_/VPB _999_/VPB sky130_fd_sc_hd__decap_12
XTAP_TAPCELL_ROW_32_199 VSUBS _999_/VPB sky130_fd_sc_hd__tapvpwrvgnd_1
XFILLER_53_241 VSUBS VSUBS _999_/VPB _999_/VPB sky130_fd_sc_hd__decap_12
XFILLER_38_271 VSUBS VSUBS _999_/VPB _999_/VPB sky130_fd_sc_hd__decap_3
XFILLER_26_24 VSUBS VSUBS _999_/VPB _999_/VPB sky130_fd_sc_hd__decap_6
XFILLER_26_79 VSUBS VSUBS _999_/VPB _999_/VPB sky130_fd_sc_hd__decap_8
XFILLER_42_67 VSUBS VSUBS _999_/VPB _999_/VPB sky130_fd_sc_hd__decap_12
XFILLER_42_12 VSUBS VSUBS _999_/VPB _999_/VPB sky130_fd_sc_hd__decap_12
XFILLER_9_109 VSUBS VSUBS _999_/VPB _999_/VPB sky130_fd_sc_hd__decap_8
XTAP_TAPCELL_ROW_23_144 VSUBS _999_/VPB sky130_fd_sc_hd__tapvpwrvgnd_1
XFILLER_5_359 VSUBS VSUBS _999_/VPB _999_/VPB sky130_fd_sc_hd__fill_1
X_625_ _895_/Q _873_/B VSUBS VSUBS _999_/VPB _999_/VPB _625_/Y sky130_fd_sc_hd__nand2_1
Xspare_inverter_2 spare_inverter_2/A VSUBS VSUBS _999_/VPB _999_/VPB spare_inverter_2/Y
+ sky130_fd_sc_hd__inv_1
X_487_ _538_/B _500_/D VSUBS VSUBS _999_/VPB _999_/VPB _488_/C sky130_fd_sc_hd__nand2_1
X_556_ CH_ENABLE[3] _540_/B _542_/Y VSUBS VSUBS _999_/VPB _999_/VPB _556_/Y sky130_fd_sc_hd__a21oi_1
XFILLER_50_211 VSUBS VSUBS _999_/VPB _999_/VPB sky130_fd_sc_hd__decap_6
XTAP_TAPCELL_ROW_45_280 VSUBS _999_/VPB sky130_fd_sc_hd__tapvpwrvgnd_1
XFILLER_35_296 VSUBS VSUBS _999_/VPB _999_/VPB sky130_fd_sc_hd__decap_4
XFILLER_35_241 VSUBS VSUBS _999_/VPB _999_/VPB sky130_fd_sc_hd__decap_12
XFILLER_58_300 VSUBS VSUBS _999_/VPB _999_/VPB sky130_fd_sc_hd__decap_4
XFILLER_2_329 VSUBS VSUBS _999_/VPB _999_/VPB sky130_fd_sc_hd__fill_1
XFILLER_2_307 VSUBS VSUBS _999_/VPB _999_/VPB sky130_fd_sc_hd__fill_2
XFILLER_37_12 VSUBS VSUBS _999_/VPB _999_/VPB sky130_fd_sc_hd__decap_12
XFILLER_41_299 VSUBS VSUBS _999_/VPB _999_/VPB sky130_fd_sc_hd__fill_1
XFILLER_5_145 VSUBS VSUBS _999_/VPB _999_/VPB sky130_fd_sc_hd__decap_12
XTAP_TAPCELL_ROW_59_361 VSUBS _999_/VPB sky130_fd_sc_hd__tapvpwrvgnd_1
XFILLER_32_211 VSUBS VSUBS _999_/VPB _999_/VPB sky130_fd_sc_hd__decap_12
X_608_ _828_/A _608_/B VSUBS VSUBS _999_/VPB _999_/VPB _891_/D sky130_fd_sc_hd__nor2_1
XFILLER_17_241 VSUBS VSUBS _999_/VPB _999_/VPB sky130_fd_sc_hd__decap_3
XFILLER_17_263 VSUBS VSUBS _999_/VPB _999_/VPB sky130_fd_sc_hd__decap_4
XFILLER_17_285 VSUBS VSUBS _999_/VPB _999_/VPB sky130_fd_sc_hd__decap_4
XTAP_TAPCELL_ROW_42_261 VSUBS _999_/VPB sky130_fd_sc_hd__tapvpwrvgnd_1
X_539_ _899_/Q _898_/Q _897_/Q _896_/Q VSUBS VSUBS _999_/VPB _999_/VPB _540_/B sky130_fd_sc_hd__nor4_1
XFILLER_55_325 VSUBS VSUBS _999_/VPB _999_/VPB sky130_fd_sc_hd__decap_12
XFILLER_23_211 VSUBS VSUBS _999_/VPB _999_/VPB sky130_fd_sc_hd__decap_12
XFILLER_23_58 VSUBS VSUBS _999_/VPB _999_/VPB sky130_fd_sc_hd__fill_2
XFILLER_48_55 VSUBS VSUBS _999_/VPB _999_/VPB sky130_fd_sc_hd__decap_12
X_890_ _981_/CLK _890_/D VSUBS VSUBS _999_/VPB _999_/VPB CRC_ERROR sky130_fd_sc_hd__dfxtp_1
XFILLER_2_115 VSUBS VSUBS _999_/VPB _999_/VPB sky130_fd_sc_hd__decap_12
XTAP_TAPCELL_ROW_56_342 VSUBS _999_/VPB sky130_fd_sc_hd__tapvpwrvgnd_1
XFILLER_46_358 VSUBS VSUBS _999_/VPB _999_/VPB sky130_fd_sc_hd__decap_8
XFILLER_14_211 VSUBS VSUBS _999_/VPB _999_/VPB sky130_fd_sc_hd__decap_12
XFILLER_49_141 VSUBS VSUBS _999_/VPB _999_/VPB sky130_fd_sc_hd__fill_1
XFILLER_1_181 VSUBS VSUBS _999_/VPB _999_/VPB sky130_fd_sc_hd__decap_12
XFILLER_20_214 VSUBS VSUBS _999_/VPB _999_/VPB sky130_fd_sc_hd__decap_12
XFILLER_9_292 VSUBS VSUBS _999_/VPB _999_/VPB sky130_fd_sc_hd__decap_8
XFILLER_55_166 VSUBS VSUBS _999_/VPB _999_/VPB sky130_fd_sc_hd__decap_4
XFILLER_55_133 VSUBS VSUBS _999_/VPB _999_/VPB sky130_fd_sc_hd__decap_12
XFILLER_28_358 VSUBS VSUBS _999_/VPB _999_/VPB sky130_fd_sc_hd__decap_8
XFILLER_51_361 VSUBS VSUBS _999_/VPB _999_/VPB sky130_fd_sc_hd__decap_8
XFILLER_50_12 VSUBS VSUBS _999_/VPB _999_/VPB sky130_fd_sc_hd__decap_12
XFILLER_34_79 VSUBS VSUBS _999_/VPB _999_/VPB sky130_fd_sc_hd__decap_8
XFILLER_34_24 VSUBS VSUBS _999_/VPB _999_/VPB sky130_fd_sc_hd__decap_6
XTAP_TAPCELL_ROW_5_39 VSUBS _999_/VPB sky130_fd_sc_hd__tapvpwrvgnd_1
Xclkload1 _981_/CLK VSUBS VSUBS _999_/VPB _999_/VPB clkload1/Y sky130_fd_sc_hd__inv_6
XFILLER_50_67 VSUBS VSUBS _999_/VPB _999_/VPB sky130_fd_sc_hd__decap_12
X_873_ _962_/Q _873_/B _873_/C VSUBS VSUBS _999_/VPB _999_/VPB _944_/D sky130_fd_sc_hd__and3_1
X_942_ _969_/CLK _942_/D VSUBS VSUBS _999_/VPB _999_/VPB _942_/Q sky130_fd_sc_hd__dfxtp_1
XFILLER_61_103 VSUBS VSUBS _999_/VPB _999_/VPB sky130_fd_sc_hd__decap_12
XFILLER_52_103 VSUBS VSUBS _999_/VPB _999_/VPB sky130_fd_sc_hd__decap_12
XFILLER_1_61 VSUBS VSUBS _999_/VPB _999_/VPB sky130_fd_sc_hd__decap_12
XFILLER_33_361 VSUBS VSUBS _999_/VPB _999_/VPB sky130_fd_sc_hd__decap_8
XFILLER_33_350 VSUBS VSUBS _999_/VPB _999_/VPB sky130_fd_sc_hd__fill_1
XFILLER_29_24 VSUBS VSUBS _999_/VPB _999_/VPB sky130_fd_sc_hd__decap_12
XFILLER_45_12 VSUBS VSUBS _999_/VPB _999_/VPB sky130_fd_sc_hd__decap_12
XTAP_TAPCELL_ROW_10_70 VSUBS _999_/VPB sky130_fd_sc_hd__tapvpwrvgnd_1
XFILLER_28_133 VSUBS VSUBS _999_/VPB _999_/VPB sky130_fd_sc_hd__fill_1
XFILLER_61_55 VSUBS VSUBS _999_/VPB _999_/VPB sky130_fd_sc_hd__decap_4
X_925_ _978_/CLK _925_/D VSUBS VSUBS _999_/VPB _999_/VPB _925_/Q sky130_fd_sc_hd__dfxtp_1
XFILLER_3_298 VSUBS VSUBS _999_/VPB _999_/VPB sky130_fd_sc_hd__fill_2
XFILLER_3_210 VSUBS VSUBS _999_/VPB _999_/VPB sky130_fd_sc_hd__decap_12
XFILLER_59_280 VSUBS VSUBS _999_/VPB _999_/VPB sky130_fd_sc_hd__decap_4
XFILLER_34_103 VSUBS VSUBS _999_/VPB _999_/VPB sky130_fd_sc_hd__decap_12
X_787_ _788_/A _794_/A VSUBS VSUBS _999_/VPB _999_/VPB _787_/Y sky130_fd_sc_hd__nor2b_1
XFILLER_19_133 VSUBS VSUBS _999_/VPB _999_/VPB sky130_fd_sc_hd__decap_4
X_856_ _970_/Q _833_/Y _587_/C VSUBS VSUBS _999_/VPB _999_/VPB _856_/Y sky130_fd_sc_hd__o21ai_0
XFILLER_30_331 VSUBS VSUBS _999_/VPB _999_/VPB sky130_fd_sc_hd__decap_12
XFILLER_15_361 VSUBS VSUBS _999_/VPB _999_/VPB sky130_fd_sc_hd__decap_8
XTAP_TAPCELL_ROW_29_183 VSUBS _999_/VPB sky130_fd_sc_hd__tapvpwrvgnd_1
XFILLER_32_0 VSUBS VSUBS _999_/VPB _999_/VPB sky130_fd_sc_hd__decap_12
XFILLER_15_48 VSUBS VSUBS _999_/VPB _999_/VPB sky130_fd_sc_hd__decap_12
XFILLER_25_169 VSUBS VSUBS _999_/VPB _999_/VPB sky130_fd_sc_hd__decap_8
XFILLER_40_139 VSUBS VSUBS _999_/VPB _999_/VPB sky130_fd_sc_hd__decap_8
XFILLER_31_36 VSUBS VSUBS _999_/VPB _999_/VPB sky130_fd_sc_hd__decap_12
XTAP_TAPCELL_ROW_2_18 VSUBS _999_/VPB sky130_fd_sc_hd__tapvpwrvgnd_1
XFILLER_0_235 VSUBS VSUBS _999_/VPB _999_/VPB sky130_fd_sc_hd__decap_4
XFILLER_56_55 VSUBS VSUBS _999_/VPB _999_/VPB sky130_fd_sc_hd__decap_12
X_710_ _921_/Q _946_/Q _722_/S VSUBS VSUBS _999_/VPB _999_/VPB _711_/B sky130_fd_sc_hd__mux2i_1
X_641_ _945_/Q _526_/C _459_/B VSUBS VSUBS _999_/VPB _999_/VPB _642_/B sky130_fd_sc_hd__o21ai_0
XFILLER_16_103 VSUBS VSUBS _999_/VPB _999_/VPB sky130_fd_sc_hd__decap_12
X_572_ _883_/Q _562_/X _587_/C VSUBS VSUBS _999_/VPB _999_/VPB _572_/Y sky130_fd_sc_hd__o21ai_0
XFILLER_31_117 VSUBS VSUBS _999_/VPB _999_/VPB sky130_fd_sc_hd__decap_3
XFILLER_12_331 VSUBS VSUBS _999_/VPB _999_/VPB sky130_fd_sc_hd__decap_12
XTAP_TAPCELL_ROW_26_164 VSUBS _999_/VPB sky130_fd_sc_hd__tapvpwrvgnd_1
X_908_ _933_/CLK _908_/D VSUBS VSUBS _999_/VPB _999_/VPB _908_/Q sky130_fd_sc_hd__dfxtp_1
XFILLER_39_217 VSUBS VSUBS _999_/VPB _999_/VPB sky130_fd_sc_hd__decap_8
XFILLER_54_209 VSUBS VSUBS _999_/VPB _999_/VPB sky130_fd_sc_hd__fill_1
X_839_ _833_/Y _837_/Y _838_/Y VSUBS VSUBS _999_/VPB _999_/VPB _964_/D sky130_fd_sc_hd__a21oi_1
XFILLER_22_139 VSUBS VSUBS _999_/VPB _999_/VPB sky130_fd_sc_hd__decap_8
XFILLER_53_253 VSUBS VSUBS _999_/VPB _999_/VPB sky130_fd_sc_hd__decap_12
XFILLER_42_24 VSUBS VSUBS _999_/VPB _999_/VPB sky130_fd_sc_hd__decap_6
XFILLER_13_117 VSUBS VSUBS _999_/VPB _999_/VPB sky130_fd_sc_hd__decap_3
XTAP_TAPCELL_ROW_23_145 VSUBS _999_/VPB sky130_fd_sc_hd__tapvpwrvgnd_1
XFILLER_42_79 VSUBS VSUBS _999_/VPB _999_/VPB sky130_fd_sc_hd__decap_8
XFILLER_5_338 VSUBS VSUBS _999_/VPB _999_/VPB sky130_fd_sc_hd__fill_1
XFILLER_21_150 VSUBS VSUBS _999_/VPB _999_/VPB sky130_fd_sc_hd__decap_3
XFILLER_3_18 VSUBS VSUBS _999_/VPB _999_/VPB sky130_fd_sc_hd__fill_1
XFILLER_36_209 VSUBS VSUBS _999_/VPB _999_/VPB sky130_fd_sc_hd__fill_1
X_555_ _559_/A _555_/B VSUBS VSUBS _999_/VPB _999_/VPB _878_/D sky130_fd_sc_hd__nor2_1
X_624_ _894_/Q _893_/Q _981_/Q VSUBS VSUBS _999_/VPB _999_/VPB _624_/Y sky130_fd_sc_hd__o21ai_0
XFILLER_16_91 VSUBS VSUBS _999_/VPB _999_/VPB sky130_fd_sc_hd__decap_12
X_486_ _895_/Q _894_/Q VSUBS VSUBS _999_/VPB _999_/VPB _500_/D sky130_fd_sc_hd__nor2_1
XTAP_TAPCELL_ROW_45_281 VSUBS _999_/VPB sky130_fd_sc_hd__tapvpwrvgnd_1
XFILLER_35_253 VSUBS VSUBS _999_/VPB _999_/VPB sky130_fd_sc_hd__decap_12
XTAP_TAPCELL_ROW_20_126 VSUBS _999_/VPB sky130_fd_sc_hd__tapvpwrvgnd_1
XFILLER_37_24 VSUBS VSUBS _999_/VPB _999_/VPB sky130_fd_sc_hd__decap_12
XFILLER_26_253 VSUBS VSUBS _999_/VPB _999_/VPB sky130_fd_sc_hd__decap_12
XFILLER_53_12 VSUBS VSUBS _999_/VPB _999_/VPB sky130_fd_sc_hd__decap_12
XFILLER_5_157 VSUBS VSUBS _999_/VPB _999_/VPB sky130_fd_sc_hd__decap_12
XTAP_TAPCELL_ROW_59_362 VSUBS _999_/VPB sky130_fd_sc_hd__tapvpwrvgnd_1
XFILLER_32_223 VSUBS VSUBS _999_/VPB _999_/VPB sky130_fd_sc_hd__decap_12
X_607_ _891_/Q _606_/B _606_/Y VSUBS VSUBS _999_/VPB _999_/VPB _608_/B sky130_fd_sc_hd__a21oi_1
X_538_ _538_/A _538_/B VSUBS VSUBS _999_/VPB _999_/VPB _538_/Y sky130_fd_sc_hd__nand2_1
XTAP_TAPCELL_ROW_42_262 VSUBS _999_/VPB sky130_fd_sc_hd__tapvpwrvgnd_1
X_469_ _975_/Q _578_/B _873_/B VSUBS VSUBS _999_/VPB _999_/VPB _469_/Y sky130_fd_sc_hd__o21ai_0
XFILLER_59_109 VSUBS VSUBS _999_/VPB _999_/VPB sky130_fd_sc_hd__decap_8
XFILLER_55_337 VSUBS VSUBS _999_/VPB _999_/VPB sky130_fd_sc_hd__fill_1
XFILLER_23_223 VSUBS VSUBS _999_/VPB _999_/VPB sky130_fd_sc_hd__decap_12
XFILLER_2_127 VSUBS VSUBS _999_/VPB _999_/VPB sky130_fd_sc_hd__decap_12
XFILLER_48_67 VSUBS VSUBS _999_/VPB _999_/VPB sky130_fd_sc_hd__decap_12
XFILLER_48_12 VSUBS VSUBS _999_/VPB _999_/VPB sky130_fd_sc_hd__decap_12
XFILLER_61_329 VSUBS VSUBS _999_/VPB _999_/VPB sky130_fd_sc_hd__fill_1
XTAP_TAPCELL_ROW_56_343 VSUBS _999_/VPB sky130_fd_sc_hd__tapvpwrvgnd_1
XFILLER_14_223 VSUBS VSUBS _999_/VPB _999_/VPB sky130_fd_sc_hd__decap_12
XFILLER_14_267 VSUBS VSUBS _999_/VPB _999_/VPB sky130_fd_sc_hd__decap_3
XFILLER_49_197 VSUBS VSUBS _999_/VPB _999_/VPB sky130_fd_sc_hd__decap_4
XFILLER_49_153 VSUBS VSUBS _999_/VPB _999_/VPB sky130_fd_sc_hd__decap_12
XFILLER_1_193 VSUBS VSUBS _999_/VPB _999_/VPB sky130_fd_sc_hd__decap_12
XTAP_TAPCELL_ROW_9_60 VSUBS _999_/VPB sky130_fd_sc_hd__tapvpwrvgnd_1
XFILLER_55_178 VSUBS VSUBS _999_/VPB _999_/VPB sky130_fd_sc_hd__fill_2
XFILLER_55_145 VSUBS VSUBS _999_/VPB _999_/VPB sky130_fd_sc_hd__decap_8
XTAP_TAPCELL_ROW_53_324 VSUBS _999_/VPB sky130_fd_sc_hd__tapvpwrvgnd_1
XFILLER_43_318 VSUBS VSUBS _999_/VPB _999_/VPB sky130_fd_sc_hd__decap_12
XFILLER_43_307 VSUBS VSUBS _999_/VPB _999_/VPB sky130_fd_sc_hd__fill_1
XFILLER_50_24 VSUBS VSUBS _999_/VPB _999_/VPB sky130_fd_sc_hd__decap_6
Xclkload2 _969_/CLK VSUBS VSUBS _999_/VPB _999_/VPB clkload2/X sky130_fd_sc_hd__clkbuf_4
XFILLER_50_79 VSUBS VSUBS _999_/VPB _999_/VPB sky130_fd_sc_hd__decap_8
X_941_ _983_/CLK _941_/D VSUBS VSUBS _999_/VPB _999_/VPB _941_/Q sky130_fd_sc_hd__dfxtp_1
X_872_ _828_/A _861_/B _871_/Y VSUBS VSUBS _999_/VPB _999_/VPB _975_/D sky130_fd_sc_hd__o21ai_0
XFILLER_61_115 VSUBS VSUBS _999_/VPB _999_/VPB sky130_fd_sc_hd__decap_4
XFILLER_46_178 VSUBS VSUBS _999_/VPB _999_/VPB sky130_fd_sc_hd__decap_12
XFILLER_34_329 VSUBS VSUBS _999_/VPB _999_/VPB sky130_fd_sc_hd__fill_1
XFILLER_24_91 VSUBS VSUBS _999_/VPB _999_/VPB sky130_fd_sc_hd__decap_12
XFILLER_52_159 VSUBS VSUBS _999_/VPB _999_/VPB sky130_fd_sc_hd__decap_12
XFILLER_52_115 VSUBS VSUBS _999_/VPB _999_/VPB sky130_fd_sc_hd__decap_12
XFILLER_1_73 VSUBS VSUBS _999_/VPB _999_/VPB sky130_fd_sc_hd__decap_12
XFILLER_25_329 VSUBS VSUBS _999_/VPB _999_/VPB sky130_fd_sc_hd__decap_12
XTAP_TAPCELL_ROW_10_71 VSUBS _999_/VPB sky130_fd_sc_hd__tapvpwrvgnd_1
XFILLER_29_36 VSUBS VSUBS _999_/VPB _999_/VPB sky130_fd_sc_hd__decap_12
XFILLER_61_12 VSUBS VSUBS _999_/VPB _999_/VPB sky130_fd_sc_hd__decap_12
XFILLER_45_24 VSUBS VSUBS _999_/VPB _999_/VPB sky130_fd_sc_hd__decap_12
XFILLER_61_89 VSUBS VSUBS _999_/VPB _999_/VPB sky130_fd_sc_hd__fill_1
X_924_ _978_/CLK _924_/D VSUBS VSUBS _999_/VPB _999_/VPB _924_/Q sky130_fd_sc_hd__dfxtp_1
XFILLER_3_222 VSUBS VSUBS _999_/VPB _999_/VPB sky130_fd_sc_hd__fill_1
XFILLER_34_115 VSUBS VSUBS _999_/VPB _999_/VPB sky130_fd_sc_hd__decap_12
XTAP_TAPCELL_ROW_29_184 VSUBS _999_/VPB sky130_fd_sc_hd__tapvpwrvgnd_1
X_786_ _940_/Q _794_/A _765_/C VSUBS VSUBS _999_/VPB _999_/VPB _788_/B sky130_fd_sc_hd__a21oi_1
X_855_ _888_/Q _969_/Q _861_/B VSUBS VSUBS _999_/VPB _999_/VPB _855_/Y sky130_fd_sc_hd__mux2i_1
XFILLER_30_354 VSUBS VSUBS _999_/VPB _999_/VPB sky130_fd_sc_hd__decap_12
XFILLER_30_343 VSUBS VSUBS _999_/VPB _999_/VPB sky130_fd_sc_hd__decap_8
XFILLER_57_207 VSUBS VSUBS _999_/VPB _999_/VPB sky130_fd_sc_hd__decap_12
XFILLER_25_0 VSUBS VSUBS _999_/VPB _999_/VPB sky130_fd_sc_hd__decap_12
XFILLER_31_48 VSUBS VSUBS _999_/VPB _999_/VPB sky130_fd_sc_hd__decap_12
XTAP_TAPCELL_ROW_2_19 VSUBS _999_/VPB sky130_fd_sc_hd__tapvpwrvgnd_1
XFILLER_21_343 VSUBS VSUBS _999_/VPB _999_/VPB sky130_fd_sc_hd__fill_1
XFILLER_0_269 VSUBS VSUBS _999_/VPB _999_/VPB sky130_fd_sc_hd__fill_1
XFILLER_56_295 VSUBS VSUBS _999_/VPB _999_/VPB sky130_fd_sc_hd__decap_12
XFILLER_56_67 VSUBS VSUBS _999_/VPB _999_/VPB sky130_fd_sc_hd__decap_12
XFILLER_56_12 VSUBS VSUBS _999_/VPB _999_/VPB sky130_fd_sc_hd__decap_12
X_640_ LAST_CMD[0] _659_/B VSUBS VSUBS _999_/VPB _999_/VPB _642_/A sky130_fd_sc_hd__nor2_1
XFILLER_16_115 VSUBS VSUBS _999_/VPB _999_/VPB sky130_fd_sc_hd__decap_12
X_571_ _551_/B _567_/Y _570_/Y _569_/Y VSUBS VSUBS _999_/VPB _999_/VPB _882_/D sky130_fd_sc_hd__a31oi_1
XFILLER_12_321 VSUBS VSUBS _999_/VPB _999_/VPB sky130_fd_sc_hd__fill_1
XFILLER_12_343 VSUBS VSUBS _999_/VPB _999_/VPB sky130_fd_sc_hd__decap_3
XFILLER_12_354 VSUBS VSUBS _999_/VPB _999_/VPB sky130_fd_sc_hd__decap_12
XTAP_TAPCELL_ROW_26_165 VSUBS _999_/VPB sky130_fd_sc_hd__tapvpwrvgnd_1
X_907_ _978_/CLK _907_/D VSUBS VSUBS _999_/VPB _999_/VPB LAST_CMD[7] sky130_fd_sc_hd__dfxtp_1
XFILLER_39_229 VSUBS VSUBS _999_/VPB _999_/VPB sky130_fd_sc_hd__decap_8
X_838_ _964_/Q _833_/Y _587_/C VSUBS VSUBS _999_/VPB _999_/VPB _838_/Y sky130_fd_sc_hd__o21ai_0
X_769_ _778_/A _792_/A VSUBS VSUBS _999_/VPB _999_/VPB _774_/A sky130_fd_sc_hd__xnor2_1
XTAP_TAPCELL_ROW_17_110 VSUBS _999_/VPB sky130_fd_sc_hd__tapvpwrvgnd_1
XFILLER_30_184 VSUBS VSUBS _999_/VPB _999_/VPB sky130_fd_sc_hd__decap_3
XFILLER_30_151 VSUBS VSUBS _999_/VPB _999_/VPB sky130_fd_sc_hd__decap_6
XFILLER_7_61 VSUBS VSUBS _999_/VPB _999_/VPB sky130_fd_sc_hd__decap_12
XFILLER_53_298 VSUBS VSUBS _999_/VPB _999_/VPB sky130_fd_sc_hd__fill_2
XFILLER_53_265 VSUBS VSUBS _999_/VPB _999_/VPB sky130_fd_sc_hd__decap_12
XTAP_TAPCELL_ROW_23_146 VSUBS _999_/VPB sky130_fd_sc_hd__tapvpwrvgnd_1
XFILLER_44_265 VSUBS VSUBS _999_/VPB _999_/VPB sky130_fd_sc_hd__fill_2
X_485_ _474_/Y _478_/Y _484_/Y VSUBS VSUBS _999_/VPB _999_/VPB _538_/B sky130_fd_sc_hd__a21bo_1
X_623_ _621_/Y _622_/X _873_/B VSUBS VSUBS _999_/VPB _999_/VPB _894_/D sky130_fd_sc_hd__o21a_1
X_554_ _554_/A _554_/B VSUBS VSUBS _999_/VPB _999_/VPB _555_/B sky130_fd_sc_hd__nand2_1
XFILLER_29_295 VSUBS VSUBS _999_/VPB _999_/VPB sky130_fd_sc_hd__fill_1
XFILLER_32_91 VSUBS VSUBS _999_/VPB _999_/VPB sky130_fd_sc_hd__decap_12
XFILLER_12_151 VSUBS VSUBS _999_/VPB _999_/VPB sky130_fd_sc_hd__decap_12
XFILLER_4_361 VSUBS VSUBS _999_/VPB _999_/VPB sky130_fd_sc_hd__decap_8
XFILLER_50_279 VSUBS VSUBS _999_/VPB _999_/VPB sky130_fd_sc_hd__decap_12
XFILLER_50_224 VSUBS VSUBS _999_/VPB _999_/VPB sky130_fd_sc_hd__decap_12
XFILLER_35_265 VSUBS VSUBS _999_/VPB _999_/VPB sky130_fd_sc_hd__decap_12
XFILLER_35_232 VSUBS VSUBS _999_/VPB _999_/VPB sky130_fd_sc_hd__fill_1
XTAP_TAPCELL_ROW_20_127 VSUBS _999_/VPB sky130_fd_sc_hd__tapvpwrvgnd_1
XFILLER_58_335 VSUBS VSUBS _999_/VPB _999_/VPB sky130_fd_sc_hd__fill_1
XFILLER_58_313 VSUBS VSUBS _999_/VPB _999_/VPB sky130_fd_sc_hd__fill_1
XFILLER_58_368 VSUBS VSUBS _999_/VPB _999_/VPB sky130_fd_sc_hd__fill_1
XFILLER_53_24 VSUBS VSUBS _999_/VPB _999_/VPB sky130_fd_sc_hd__decap_12
XFILLER_37_36 VSUBS VSUBS _999_/VPB _999_/VPB sky130_fd_sc_hd__decap_12
XFILLER_26_265 VSUBS VSUBS _999_/VPB _999_/VPB sky130_fd_sc_hd__decap_4
XFILLER_26_287 VSUBS VSUBS _999_/VPB _999_/VPB sky130_fd_sc_hd__decap_12
XFILLER_41_279 VSUBS VSUBS _999_/VPB _999_/VPB sky130_fd_sc_hd__decap_12
XFILLER_5_169 VSUBS VSUBS _999_/VPB _999_/VPB sky130_fd_sc_hd__decap_8
XTAP_TAPCELL_ROW_59_363 VSUBS _999_/VPB sky130_fd_sc_hd__tapvpwrvgnd_1
XFILLER_49_357 VSUBS VSUBS _999_/VPB _999_/VPB sky130_fd_sc_hd__decap_3
XTAP_TAPCELL_ROW_42_263 VSUBS _999_/VPB sky130_fd_sc_hd__tapvpwrvgnd_1
X_537_ _723_/A _537_/B VSUBS VSUBS _999_/VPB _999_/VPB _875_/D sky130_fd_sc_hd__nor2_1
XFILLER_32_235 VSUBS VSUBS _999_/VPB _999_/VPB sky130_fd_sc_hd__fill_1
XFILLER_17_232 VSUBS VSUBS _999_/VPB _999_/VPB sky130_fd_sc_hd__decap_8
X_468_ _545_/B _545_/C VSUBS VSUBS _999_/VPB _999_/VPB _578_/B sky130_fd_sc_hd__and2_0
X_606_ _891_/Q _606_/B _606_/C VSUBS VSUBS _999_/VPB _999_/VPB _606_/Y sky130_fd_sc_hd__nor3_1
Xload_slew1 _587_/C VSUBS VSUBS _999_/VPB _999_/VPB _459_/B sky130_fd_sc_hd__buf_8
XFILLER_23_235 VSUBS VSUBS _999_/VPB _999_/VPB sky130_fd_sc_hd__fill_2
XFILLER_2_139 VSUBS VSUBS _999_/VPB _999_/VPB sky130_fd_sc_hd__decap_8
XFILLER_58_187 VSUBS VSUBS _999_/VPB _999_/VPB sky130_fd_sc_hd__decap_8
XFILLER_48_79 VSUBS VSUBS _999_/VPB _999_/VPB sky130_fd_sc_hd__decap_8
XFILLER_48_24 VSUBS VSUBS _999_/VPB _999_/VPB sky130_fd_sc_hd__decap_6
XTAP_TAPCELL_ROW_56_344 VSUBS _999_/VPB sky130_fd_sc_hd__tapvpwrvgnd_1
XFILLER_14_235 VSUBS VSUBS _999_/VPB _999_/VPB sky130_fd_sc_hd__decap_12
XFILLER_49_121 VSUBS VSUBS _999_/VPB _999_/VPB sky130_fd_sc_hd__decap_12
Xclkbuf_3_7__f_clk clkbuf_0_clk/X VSUBS VSUBS _999_/VPB _999_/VPB _959_/CLK sky130_fd_sc_hd__clkbuf_16
XFILLER_49_165 VSUBS VSUBS _999_/VPB _999_/VPB sky130_fd_sc_hd__decap_6
XTAP_TAPCELL_ROW_9_61 VSUBS _999_/VPB sky130_fd_sc_hd__tapvpwrvgnd_1
XFILLER_55_0 VSUBS VSUBS _999_/VPB _999_/VPB sky130_fd_sc_hd__decap_12
XFILLER_28_338 VSUBS VSUBS _999_/VPB _999_/VPB sky130_fd_sc_hd__decap_6
XTAP_TAPCELL_ROW_53_325 VSUBS _999_/VPB sky130_fd_sc_hd__tapvpwrvgnd_1
XTAP_TAPCELL_ROW_61_380 VSUBS _999_/VPB sky130_fd_sc_hd__tapvpwrvgnd_1
XFILLER_7_209 VSUBS VSUBS _999_/VPB _999_/VPB sky130_fd_sc_hd__decap_12
Xclkload3 _970_/CLK VSUBS VSUBS _999_/VPB _999_/VPB clkload3/Y sky130_fd_sc_hd__inv_6
XFILLER_59_12 VSUBS VSUBS _999_/VPB _999_/VPB sky130_fd_sc_hd__decap_12
X_940_ _983_/CLK _940_/D VSUBS VSUBS _999_/VPB _999_/VPB _940_/Q sky130_fd_sc_hd__dfxtp_1
X_871_ _975_/Q _873_/B _871_/C VSUBS VSUBS _999_/VPB _999_/VPB _871_/Y sky130_fd_sc_hd__nand3_1
XFILLER_61_149 VSUBS VSUBS _999_/VPB _999_/VPB sky130_fd_sc_hd__fill_1
XFILLER_40_91 VSUBS VSUBS _999_/VPB _999_/VPB sky130_fd_sc_hd__decap_12
XFILLER_10_271 VSUBS VSUBS _999_/VPB _999_/VPB sky130_fd_sc_hd__decap_12
XFILLER_52_127 VSUBS VSUBS _999_/VPB _999_/VPB sky130_fd_sc_hd__decap_6
XTAP_TAPCELL_ROW_50_306 VSUBS _999_/VPB sky130_fd_sc_hd__tapvpwrvgnd_1
XFILLER_1_85 VSUBS VSUBS _999_/VPB _999_/VPB sky130_fd_sc_hd__decap_12
XFILLER_45_36 VSUBS VSUBS _999_/VPB _999_/VPB sky130_fd_sc_hd__decap_12
XFILLER_43_105 VSUBS VSUBS _999_/VPB _999_/VPB sky130_fd_sc_hd__fill_1
XFILLER_28_157 VSUBS VSUBS _999_/VPB _999_/VPB sky130_fd_sc_hd__decap_12
XFILLER_29_48 VSUBS VSUBS _999_/VPB _999_/VPB sky130_fd_sc_hd__decap_12
XFILLER_61_24 VSUBS VSUBS _999_/VPB _999_/VPB sky130_fd_sc_hd__decap_6
X_923_ _959_/CLK _923_/D VSUBS VSUBS _999_/VPB _999_/VPB _923_/Q sky130_fd_sc_hd__dfxtp_1
X_854_ _833_/Y _852_/Y _853_/Y VSUBS VSUBS _999_/VPB _999_/VPB _969_/D sky130_fd_sc_hd__a21oi_1
XFILLER_3_256 VSUBS VSUBS _999_/VPB _999_/VPB sky130_fd_sc_hd__decap_3
XFILLER_34_149 VSUBS VSUBS _999_/VPB _999_/VPB sky130_fd_sc_hd__fill_1
XFILLER_34_127 VSUBS VSUBS _999_/VPB _999_/VPB sky130_fd_sc_hd__decap_12
XTAP_TAPCELL_ROW_29_185 VSUBS _999_/VPB sky130_fd_sc_hd__tapvpwrvgnd_1
X_785_ _941_/Q _797_/A VSUBS VSUBS _999_/VPB _999_/VPB _794_/A sky130_fd_sc_hd__xnor2_1
XFILLER_19_146 VSUBS VSUBS _999_/VPB _999_/VPB sky130_fd_sc_hd__fill_2
XFILLER_19_179 VSUBS VSUBS _999_/VPB _999_/VPB sky130_fd_sc_hd__fill_1
XFILLER_30_366 VSUBS VSUBS _999_/VPB _999_/VPB sky130_fd_sc_hd__decap_3
XFILLER_57_219 VSUBS VSUBS _999_/VPB _999_/VPB sky130_fd_sc_hd__decap_8
XFILLER_18_0 VSUBS VSUBS _999_/VPB _999_/VPB sky130_fd_sc_hd__decap_12
XFILLER_56_79 VSUBS VSUBS _999_/VPB _999_/VPB sky130_fd_sc_hd__decap_8
XFILLER_56_24 VSUBS VSUBS _999_/VPB _999_/VPB sky130_fd_sc_hd__decap_6
X_570_ _937_/Q _765_/B VSUBS VSUBS _999_/VPB _999_/VPB _570_/Y sky130_fd_sc_hd__nand2_1
XFILLER_16_127 VSUBS VSUBS _999_/VPB _999_/VPB sky130_fd_sc_hd__decap_4
XFILLER_16_149 VSUBS VSUBS _999_/VPB _999_/VPB sky130_fd_sc_hd__fill_1
XFILLER_12_366 VSUBS VSUBS _999_/VPB _999_/VPB sky130_fd_sc_hd__decap_3
XTAP_TAPCELL_ROW_26_166 VSUBS _999_/VPB sky130_fd_sc_hd__tapvpwrvgnd_1
XFILLER_47_241 VSUBS VSUBS _999_/VPB _999_/VPB sky130_fd_sc_hd__decap_12
X_906_ _978_/CLK _906_/D VSUBS VSUBS _999_/VPB _999_/VPB LAST_CMD[6] sky130_fd_sc_hd__dfxtp_1
X_768_ _937_/Q _877_/Q VSUBS VSUBS _999_/VPB _999_/VPB _792_/A sky130_fd_sc_hd__xor2_1
X_837_ _882_/Q _963_/Q _861_/B VSUBS VSUBS _999_/VPB _999_/VPB _837_/Y sky130_fd_sc_hd__mux2i_1
X_699_ _703_/A _697_/B CH_ENABLE[1] VSUBS VSUBS _999_/VPB _999_/VPB _700_/C sky130_fd_sc_hd__a21oi_1
Xclkbuf_0_clk clk VSUBS VSUBS _999_/VPB _999_/VPB clkbuf_0_clk/X sky130_fd_sc_hd__clkbuf_16
XFILLER_15_171 VSUBS VSUBS _999_/VPB _999_/VPB sky130_fd_sc_hd__decap_8
XTAP_TAPCELL_ROW_17_111 VSUBS _999_/VPB sky130_fd_sc_hd__tapvpwrvgnd_1
XFILLER_7_73 VSUBS VSUBS _999_/VPB _999_/VPB sky130_fd_sc_hd__decap_12
XFILLER_53_200 VSUBS VSUBS _999_/VPB _999_/VPB sky130_fd_sc_hd__decap_12
XFILLER_53_277 VSUBS VSUBS _999_/VPB _999_/VPB sky130_fd_sc_hd__decap_12
XTAP_TAPCELL_ROW_23_147 VSUBS _999_/VPB sky130_fd_sc_hd__tapvpwrvgnd_1
X_622_ _981_/Q _622_/B _622_/C VSUBS VSUBS _999_/VPB _999_/VPB _622_/X sky130_fd_sc_hd__and3_1
XFILLER_29_241 VSUBS VSUBS _999_/VPB _999_/VPB sky130_fd_sc_hd__decap_12
XFILLER_44_233 VSUBS VSUBS _999_/VPB _999_/VPB sky130_fd_sc_hd__decap_12
XFILLER_44_211 VSUBS VSUBS _999_/VPB _999_/VPB sky130_fd_sc_hd__decap_8
X_484_ CH_PC_READY _474_/A _474_/B _483_/X VSUBS VSUBS _999_/VPB _999_/VPB _484_/Y
+ sky130_fd_sc_hd__a31oi_1
X_553_ _541_/X _552_/Y _540_/Y VSUBS VSUBS _999_/VPB _999_/VPB _554_/B sky130_fd_sc_hd__o21ai_0
XFILLER_8_167 VSUBS VSUBS _999_/VPB _999_/VPB sky130_fd_sc_hd__fill_1
XFILLER_12_163 VSUBS VSUBS _999_/VPB _999_/VPB sky130_fd_sc_hd__decap_8
XTAP_TAPCELL_ROW_37_228 VSUBS _999_/VPB sky130_fd_sc_hd__tapvpwrvgnd_1
XFILLER_50_236 VSUBS VSUBS _999_/VPB _999_/VPB sky130_fd_sc_hd__decap_6
XTAP_TAPCELL_ROW_20_128 VSUBS _999_/VPB sky130_fd_sc_hd__tapvpwrvgnd_1
XFILLER_37_48 VSUBS VSUBS _999_/VPB _999_/VPB sky130_fd_sc_hd__decap_12
XFILLER_53_36 VSUBS VSUBS _999_/VPB _999_/VPB sky130_fd_sc_hd__decap_12
XFILLER_41_214 VSUBS VSUBS _999_/VPB _999_/VPB sky130_fd_sc_hd__fill_2
XFILLER_26_211 VSUBS VSUBS _999_/VPB _999_/VPB sky130_fd_sc_hd__decap_8
XFILLER_26_299 VSUBS VSUBS _999_/VPB _999_/VPB sky130_fd_sc_hd__decap_12
XTAP_TAPCELL_ROW_59_364 VSUBS _999_/VPB sky130_fd_sc_hd__tapvpwrvgnd_1
XFILLER_49_325 VSUBS VSUBS _999_/VPB _999_/VPB sky130_fd_sc_hd__decap_12
X_605_ _892_/Q _977_/Q VSUBS VSUBS _999_/VPB _999_/VPB _606_/C sky130_fd_sc_hd__nand2_1
X_536_ _875_/Q _526_/C _526_/Y _535_/Y VSUBS VSUBS _999_/VPB _999_/VPB _537_/B sky130_fd_sc_hd__a22oi_1
XFILLER_32_269 VSUBS VSUBS _999_/VPB _999_/VPB sky130_fd_sc_hd__fill_1
X_467_ _898_/Q _449_/Y _899_/Q VSUBS VSUBS _999_/VPB _999_/VPB _545_/C sky130_fd_sc_hd__a21oi_1
XTAP_TAPCELL_ROW_56_345 VSUBS _999_/VPB sky130_fd_sc_hd__tapvpwrvgnd_1
XFILLER_46_317 VSUBS VSUBS _999_/VPB _999_/VPB sky130_fd_sc_hd__decap_12
XFILLER_14_247 VSUBS VSUBS _999_/VPB _999_/VPB sky130_fd_sc_hd__decap_12
XFILLER_13_61 VSUBS VSUBS _999_/VPB _999_/VPB sky130_fd_sc_hd__decap_12
XFILLER_49_133 VSUBS VSUBS _999_/VPB _999_/VPB sky130_fd_sc_hd__decap_8
XFILLER_60_331 VSUBS VSUBS _999_/VPB _999_/VPB sky130_fd_sc_hd__decap_12
XFILLER_45_361 VSUBS VSUBS _999_/VPB _999_/VPB sky130_fd_sc_hd__decap_8
XFILLER_38_91 VSUBS VSUBS _999_/VPB _999_/VPB sky130_fd_sc_hd__decap_12
XTAP_TAPCELL_ROW_9_62 VSUBS _999_/VPB sky130_fd_sc_hd__tapvpwrvgnd_1
XFILLER_9_284 VSUBS VSUBS _999_/VPB _999_/VPB sky130_fd_sc_hd__fill_1
XFILLER_13_280 VSUBS VSUBS _999_/VPB _999_/VPB sky130_fd_sc_hd__decap_6
X_519_ _976_/Q _495_/Y _518_/Y VSUBS VSUBS _999_/VPB _999_/VPB _520_/B sky130_fd_sc_hd__a21oi_1
XFILLER_48_0 VSUBS VSUBS _999_/VPB _999_/VPB sky130_fd_sc_hd__decap_12
XTAP_TAPCELL_ROW_53_326 VSUBS _999_/VPB sky130_fd_sc_hd__tapvpwrvgnd_1
XFILLER_51_331 VSUBS VSUBS _999_/VPB _999_/VPB sky130_fd_sc_hd__decap_4
XFILLER_36_350 VSUBS VSUBS _999_/VPB _999_/VPB sky130_fd_sc_hd__decap_12
XFILLER_11_217 VSUBS VSUBS _999_/VPB _999_/VPB sky130_fd_sc_hd__fill_1
XTAP_TAPCELL_ROW_61_381 VSUBS _999_/VPB sky130_fd_sc_hd__tapvpwrvgnd_1
Xclkload4 _982_/CLK VSUBS VSUBS _999_/VPB _999_/VPB clkload4/Y sky130_fd_sc_hd__inv_6
XFILLER_59_24 VSUBS VSUBS _999_/VPB _999_/VPB sky130_fd_sc_hd__decap_12
X_870_ _971_/Q ESPI_BIT_TICK _870_/C VSUBS VSUBS _999_/VPB _999_/VPB _871_/C sky130_fd_sc_hd__nand3_1
XFILLER_46_103 VSUBS VSUBS _999_/VPB _999_/VPB sky130_fd_sc_hd__decap_12
XFILLER_42_331 VSUBS VSUBS _999_/VPB _999_/VPB sky130_fd_sc_hd__decap_12
XFILLER_34_309 VSUBS VSUBS _999_/VPB _999_/VPB sky130_fd_sc_hd__decap_12
XFILLER_27_361 VSUBS VSUBS _999_/VPB _999_/VPB sky130_fd_sc_hd__decap_8
XFILLER_54_191 VSUBS VSUBS _999_/VPB _999_/VPB sky130_fd_sc_hd__decap_12
XFILLER_10_283 VSUBS VSUBS _999_/VPB _999_/VPB sky130_fd_sc_hd__fill_1
X_999_ VSUBS VSUBS _999_/VPB _999_/VPB _999_/HI STATUS_REG[15] sky130_fd_sc_hd__conb_1
XTAP_TAPCELL_ROW_50_307 VSUBS _999_/VPB sky130_fd_sc_hd__tapvpwrvgnd_1
XFILLER_1_97 VSUBS VSUBS _999_/VPB _999_/VPB sky130_fd_sc_hd__decap_12
XFILLER_45_48 VSUBS VSUBS _999_/VPB _999_/VPB sky130_fd_sc_hd__decap_12
XFILLER_28_103 VSUBS VSUBS _999_/VPB _999_/VPB sky130_fd_sc_hd__decap_12
XFILLER_28_169 VSUBS VSUBS _999_/VPB _999_/VPB sky130_fd_sc_hd__decap_12
XFILLER_24_331 VSUBS VSUBS _999_/VPB _999_/VPB sky130_fd_sc_hd__decap_12
X_922_ _959_/CLK _922_/D VSUBS VSUBS _999_/VPB _999_/VPB _922_/Q sky130_fd_sc_hd__dfxtp_1
X_853_ _969_/Q _833_/Y _587_/C VSUBS VSUBS _999_/VPB _999_/VPB _853_/Y sky130_fd_sc_hd__o21ai_0
X_784_ _942_/Q _791_/B VSUBS VSUBS _999_/VPB _999_/VPB _797_/A sky130_fd_sc_hd__xnor2_1
XFILLER_34_139 VSUBS VSUBS _999_/VPB _999_/VPB sky130_fd_sc_hd__fill_2
XFILLER_15_331 VSUBS VSUBS _999_/VPB _999_/VPB sky130_fd_sc_hd__decap_8
XFILLER_25_117 VSUBS VSUBS _999_/VPB _999_/VPB sky130_fd_sc_hd__decap_3
XFILLER_21_301 VSUBS VSUBS _999_/VPB _999_/VPB sky130_fd_sc_hd__decap_12
XFILLER_0_205 VSUBS VSUBS _999_/VPB _999_/VPB sky130_fd_sc_hd__decap_4
XFILLER_31_109 VSUBS VSUBS _999_/VPB _999_/VPB sky130_fd_sc_hd__decap_8
XTAP_TAPCELL_ROW_26_167 VSUBS _999_/VPB sky130_fd_sc_hd__tapvpwrvgnd_1
XFILLER_8_327 VSUBS VSUBS _999_/VPB _999_/VPB sky130_fd_sc_hd__decap_3
XFILLER_8_349 VSUBS VSUBS _999_/VPB _999_/VPB sky130_fd_sc_hd__decap_12
X_905_ _978_/CLK _905_/D VSUBS VSUBS _999_/VPB _999_/VPB LAST_CMD[5] sky130_fd_sc_hd__dfxtp_1
XFILLER_21_61 VSUBS VSUBS _999_/VPB _999_/VPB sky130_fd_sc_hd__decap_12
XFILLER_47_297 VSUBS VSUBS _999_/VPB _999_/VPB sky130_fd_sc_hd__decap_3
XFILLER_47_253 VSUBS VSUBS _999_/VPB _999_/VPB sky130_fd_sc_hd__decap_12
X_767_ _938_/Q _878_/Q VSUBS VSUBS _999_/VPB _999_/VPB _778_/A sky130_fd_sc_hd__xor2_1
X_836_ _836_/A _836_/B VSUBS VSUBS _999_/VPB _999_/VPB _963_/D sky130_fd_sc_hd__nor2_1
XFILLER_46_91 VSUBS VSUBS _999_/VPB _999_/VPB sky130_fd_sc_hd__decap_12
X_698_ _945_/Q _978_/Q _697_/Y VSUBS VSUBS _999_/VPB _999_/VPB _700_/B sky130_fd_sc_hd__a21oi_1
XTAP_TAPCELL_ROW_17_112 VSUBS _999_/VPB sky130_fd_sc_hd__tapvpwrvgnd_1
XFILLER_7_85 VSUBS VSUBS _999_/VPB _999_/VPB sky130_fd_sc_hd__decap_12
XFILLER_30_0 VSUBS VSUBS _999_/VPB _999_/VPB sky130_fd_sc_hd__decap_12
XFILLER_53_289 VSUBS VSUBS _999_/VPB _999_/VPB sky130_fd_sc_hd__fill_2
XFILLER_53_212 VSUBS VSUBS _999_/VPB _999_/VPB sky130_fd_sc_hd__decap_12
XFILLER_13_109 VSUBS VSUBS _999_/VPB _999_/VPB sky130_fd_sc_hd__decap_8
XTAP_TAPCELL_ROW_31_192 VSUBS _999_/VPB sky130_fd_sc_hd__tapvpwrvgnd_1
XFILLER_21_142 VSUBS VSUBS _999_/VPB _999_/VPB sky130_fd_sc_hd__decap_8
XFILLER_21_197 VSUBS VSUBS _999_/VPB _999_/VPB sky130_fd_sc_hd__decap_12
XTAP_TAPCELL_ROW_23_148 VSUBS _999_/VPB sky130_fd_sc_hd__tapvpwrvgnd_1
X_621_ _622_/C _618_/Y _894_/Q VSUBS VSUBS _999_/VPB _999_/VPB _621_/Y sky130_fd_sc_hd__a21boi_0
XFILLER_29_253 VSUBS VSUBS _999_/VPB _999_/VPB sky130_fd_sc_hd__decap_12
XFILLER_44_245 VSUBS VSUBS _999_/VPB _999_/VPB sky130_fd_sc_hd__decap_12
X_483_ _480_/Y _481_/Y _482_/Y _478_/A VSUBS VSUBS _999_/VPB _999_/VPB _483_/X sky130_fd_sc_hd__o31a_1
X_552_ CH_ENABLE[2] _540_/B _542_/Y VSUBS VSUBS _999_/VPB _999_/VPB _552_/Y sky130_fd_sc_hd__a21oi_1
X_819_ _958_/Q _822_/B VSUBS VSUBS _999_/VPB _999_/VPB _821_/A sky130_fd_sc_hd__nor2_1
XTAP_TAPCELL_ROW_37_229 VSUBS _999_/VPB sky130_fd_sc_hd__tapvpwrvgnd_1
XFILLER_35_201 VSUBS VSUBS _999_/VPB _999_/VPB sky130_fd_sc_hd__fill_2
XTAP_TAPCELL_ROW_20_129 VSUBS _999_/VPB sky130_fd_sc_hd__tapvpwrvgnd_1
XFILLER_58_304 VSUBS VSUBS _999_/VPB _999_/VPB sky130_fd_sc_hd__fill_1
XFILLER_53_48 VSUBS VSUBS _999_/VPB _999_/VPB sky130_fd_sc_hd__decap_12
XFILLER_49_337 VSUBS VSUBS _999_/VPB _999_/VPB sky130_fd_sc_hd__decap_12
XTAP_TAPCELL_ROW_59_365 VSUBS _999_/VPB sky130_fd_sc_hd__tapvpwrvgnd_1
X_535_ _948_/Q _535_/B _535_/C VSUBS VSUBS _999_/VPB _999_/VPB _535_/Y sky130_fd_sc_hd__nor3_1
X_604_ _980_/Q _602_/Y _513_/Y VSUBS VSUBS _999_/VPB _999_/VPB _606_/B sky130_fd_sc_hd__o21a_1
XFILLER_17_267 VSUBS VSUBS _999_/VPB _999_/VPB sky130_fd_sc_hd__fill_1
XFILLER_17_289 VSUBS VSUBS _999_/VPB _999_/VPB sky130_fd_sc_hd__fill_1
X_466_ _898_/Q _449_/Y _524_/A _897_/Q VSUBS VSUBS _999_/VPB _999_/VPB _545_/B sky130_fd_sc_hd__o22ai_1
XFILLER_4_31 VSUBS VSUBS _999_/VPB _999_/VPB sky130_fd_sc_hd__decap_12
XFILLER_23_18 VSUBS VSUBS _999_/VPB _999_/VPB sky130_fd_sc_hd__fill_1
XTAP_TAPCELL_ROW_13_84 VSUBS _999_/VPB sky130_fd_sc_hd__tapvpwrvgnd_1
XFILLER_58_167 VSUBS VSUBS _999_/VPB _999_/VPB sky130_fd_sc_hd__fill_1
XFILLER_58_145 VSUBS VSUBS _999_/VPB _999_/VPB sky130_fd_sc_hd__fill_1
XTAP_TAPCELL_ROW_56_346 VSUBS _999_/VPB sky130_fd_sc_hd__tapvpwrvgnd_1
XFILLER_46_329 VSUBS VSUBS _999_/VPB _999_/VPB sky130_fd_sc_hd__fill_1
XFILLER_14_259 VSUBS VSUBS _999_/VPB _999_/VPB sky130_fd_sc_hd__decap_8
XTAP_TAPCELL_ROW_0_10 VSUBS _999_/VPB sky130_fd_sc_hd__tapvpwrvgnd_1
XFILLER_8_0 VSUBS VSUBS _999_/VPB _999_/VPB sky130_fd_sc_hd__decap_12
XFILLER_13_73 VSUBS VSUBS _999_/VPB _999_/VPB sky130_fd_sc_hd__decap_12
XFILLER_49_178 VSUBS VSUBS _999_/VPB _999_/VPB sky130_fd_sc_hd__fill_2
XFILLER_60_343 VSUBS VSUBS _999_/VPB _999_/VPB sky130_fd_sc_hd__decap_12
XFILLER_54_91 VSUBS VSUBS _999_/VPB _999_/VPB sky130_fd_sc_hd__decap_12
XFILLER_45_351 VSUBS VSUBS _999_/VPB _999_/VPB sky130_fd_sc_hd__decap_8
X_518_ _873_/B _518_/B VSUBS VSUBS _999_/VPB _999_/VPB _518_/Y sky130_fd_sc_hd__nand2_1
XTAP_TAPCELL_ROW_9_63 VSUBS _999_/VPB sky130_fd_sc_hd__tapvpwrvgnd_1
X_449_ _875_/Q VSUBS VSUBS _999_/VPB _999_/VPB _449_/Y sky130_fd_sc_hd__clkinv_1
XFILLER_36_362 VSUBS VSUBS _999_/VPB _999_/VPB sky130_fd_sc_hd__decap_6
XTAP_TAPCELL_ROW_61_382 VSUBS _999_/VPB sky130_fd_sc_hd__tapvpwrvgnd_1
XTAP_TAPCELL_ROW_53_327 VSUBS _999_/VPB sky130_fd_sc_hd__tapvpwrvgnd_1
Xclkload5 _933_/CLK VSUBS VSUBS _999_/VPB _999_/VPB clkload5/Y sky130_fd_sc_hd__inv_6
XFILLER_59_36 VSUBS VSUBS _999_/VPB _999_/VPB sky130_fd_sc_hd__decap_12
XFILLER_46_115 VSUBS VSUBS _999_/VPB _999_/VPB sky130_fd_sc_hd__decap_12
XFILLER_42_343 VSUBS VSUBS _999_/VPB _999_/VPB sky130_fd_sc_hd__decap_4
XFILLER_6_211 VSUBS VSUBS _999_/VPB _999_/VPB sky130_fd_sc_hd__decap_12
XFILLER_6_277 VSUBS VSUBS _999_/VPB _999_/VPB sky130_fd_sc_hd__decap_12
X_998_ VSUBS VSUBS _999_/VPB _999_/VPB _998_/HI STATUS_REG[14] sky130_fd_sc_hd__conb_1
XFILLER_60_151 VSUBS VSUBS _999_/VPB _999_/VPB sky130_fd_sc_hd__decap_12
XTAP_TAPCELL_ROW_50_308 VSUBS _999_/VPB sky130_fd_sc_hd__tapvpwrvgnd_1
XFILLER_45_181 VSUBS VSUBS _999_/VPB _999_/VPB sky130_fd_sc_hd__decap_12
XFILLER_60_0 VSUBS VSUBS _999_/VPB _999_/VPB sky130_fd_sc_hd__decap_12
XFILLER_43_118 VSUBS VSUBS _999_/VPB _999_/VPB sky130_fd_sc_hd__fill_2
XFILLER_24_343 VSUBS VSUBS _999_/VPB _999_/VPB sky130_fd_sc_hd__decap_12
XFILLER_28_115 VSUBS VSUBS _999_/VPB _999_/VPB sky130_fd_sc_hd__decap_12
XFILLER_61_59 VSUBS VSUBS _999_/VPB _999_/VPB sky130_fd_sc_hd__fill_1
X_921_ _959_/CLK _921_/D VSUBS VSUBS _999_/VPB _999_/VPB _921_/Q sky130_fd_sc_hd__dfxtp_1
XFILLER_3_269 VSUBS VSUBS _999_/VPB _999_/VPB sky130_fd_sc_hd__fill_2
X_852_ _887_/Q _968_/Q _861_/B VSUBS VSUBS _999_/VPB _999_/VPB _852_/Y sky130_fd_sc_hd__mux2i_1
X_783_ _828_/A _783_/B VSUBS VSUBS _999_/VPB _999_/VPB _939_/D sky130_fd_sc_hd__nor2_1
XFILLER_19_61 VSUBS VSUBS _999_/VPB _999_/VPB sky130_fd_sc_hd__decap_12
XFILLER_42_151 VSUBS VSUBS _999_/VPB _999_/VPB sky130_fd_sc_hd__decap_12
XTAP_TAPCELL_ROW_6_42 VSUBS _999_/VPB sky130_fd_sc_hd__tapvpwrvgnd_1
XFILLER_27_181 VSUBS VSUBS _999_/VPB _999_/VPB sky130_fd_sc_hd__decap_12
XFILLER_21_313 VSUBS VSUBS _999_/VPB _999_/VPB sky130_fd_sc_hd__decap_12
XFILLER_0_239 VSUBS VSUBS _999_/VPB _999_/VPB sky130_fd_sc_hd__fill_1
XFILLER_24_151 VSUBS VSUBS _999_/VPB _999_/VPB sky130_fd_sc_hd__decap_12
XFILLER_21_73 VSUBS VSUBS _999_/VPB _999_/VPB sky130_fd_sc_hd__decap_12
X_904_ _978_/CLK _904_/D VSUBS VSUBS _999_/VPB _999_/VPB LAST_CMD[4] sky130_fd_sc_hd__dfxtp_1
XFILLER_47_265 VSUBS VSUBS _999_/VPB _999_/VPB sky130_fd_sc_hd__decap_12
X_697_ _703_/A _697_/B VSUBS VSUBS _999_/VPB _999_/VPB _697_/Y sky130_fd_sc_hd__nand2_1
X_766_ _936_/Q _876_/Q VSUBS VSUBS _999_/VPB _999_/VPB _791_/B sky130_fd_sc_hd__xor2_1
XTAP_TAPCELL_ROW_17_113 VSUBS _999_/VPB sky130_fd_sc_hd__tapvpwrvgnd_1
X_835_ _963_/Q _833_/Y _587_/C VSUBS VSUBS _999_/VPB _999_/VPB _836_/B sky130_fd_sc_hd__o21ai_0
XFILLER_30_176 VSUBS VSUBS _999_/VPB _999_/VPB sky130_fd_sc_hd__decap_8
XFILLER_7_97 VSUBS VSUBS _999_/VPB _999_/VPB sky130_fd_sc_hd__decap_12
XFILLER_7_361 VSUBS VSUBS _999_/VPB _999_/VPB sky130_fd_sc_hd__decap_8
XFILLER_23_0 VSUBS VSUBS _999_/VPB _999_/VPB sky130_fd_sc_hd__decap_12
XFILLER_53_224 VSUBS VSUBS _999_/VPB _999_/VPB sky130_fd_sc_hd__decap_12
XFILLER_38_265 VSUBS VSUBS _999_/VPB _999_/VPB sky130_fd_sc_hd__decap_4
XFILLER_21_121 VSUBS VSUBS _999_/VPB _999_/VPB sky130_fd_sc_hd__decap_12
XTAP_TAPCELL_ROW_31_193 VSUBS _999_/VPB sky130_fd_sc_hd__tapvpwrvgnd_1
XTAP_TAPCELL_ROW_23_149 VSUBS _999_/VPB sky130_fd_sc_hd__tapvpwrvgnd_1
X_620_ _828_/A _620_/B VSUBS VSUBS _999_/VPB _999_/VPB _893_/D sky130_fd_sc_hd__nor2_1
X_551_ _559_/A _551_/B VSUBS VSUBS _999_/VPB _999_/VPB _877_/D sky130_fd_sc_hd__nor2_1
XFILLER_29_265 VSUBS VSUBS _999_/VPB _999_/VPB sky130_fd_sc_hd__decap_12
XFILLER_44_257 VSUBS VSUBS _999_/VPB _999_/VPB sky130_fd_sc_hd__decap_8
X_482_ LAST_CMD[3] LAST_CMD[1] CH_FLASH_READY LAST_CMD[2] VSUBS VSUBS _999_/VPB _999_/VPB
+ _482_/Y sky130_fd_sc_hd__nor4bb_1
XFILLER_8_103 VSUBS VSUBS _999_/VPB _999_/VPB sky130_fd_sc_hd__decap_12
XFILLER_12_187 VSUBS VSUBS _999_/VPB _999_/VPB sky130_fd_sc_hd__decap_12
XFILLER_4_331 VSUBS VSUBS _999_/VPB _999_/VPB sky130_fd_sc_hd__decap_6
XFILLER_8_147 VSUBS VSUBS _999_/VPB _999_/VPB sky130_fd_sc_hd__decap_3
X_818_ _818_/A _818_/B VSUBS VSUBS _999_/VPB _999_/VPB _957_/D sky130_fd_sc_hd__nor2_1
X_749_ _749_/A _755_/A VSUBS VSUBS _999_/VPB _999_/VPB _749_/Y sky130_fd_sc_hd__xnor2_1
XFILLER_41_238 VSUBS VSUBS _999_/VPB _999_/VPB sky130_fd_sc_hd__fill_2
XFILLER_5_117 VSUBS VSUBS _999_/VPB _999_/VPB sky130_fd_sc_hd__decap_3
XFILLER_1_301 VSUBS VSUBS _999_/VPB _999_/VPB sky130_fd_sc_hd__decap_12
XFILLER_49_349 VSUBS VSUBS _999_/VPB _999_/VPB sky130_fd_sc_hd__decap_8
X_534_ _534_/A _534_/B VSUBS VSUBS _999_/VPB _999_/VPB _535_/C sky130_fd_sc_hd__nand2_1
X_603_ _541_/C _508_/B _980_/Q VSUBS VSUBS _999_/VPB _999_/VPB _603_/Y sky130_fd_sc_hd__o21ai_0
X_465_ _979_/Q _516_/A VSUBS VSUBS _999_/VPB _999_/VPB _465_/Y sky130_fd_sc_hd__nand2_1
XFILLER_27_61 VSUBS VSUBS _999_/VPB _999_/VPB sky130_fd_sc_hd__decap_12
XFILLER_40_271 VSUBS VSUBS _999_/VPB _999_/VPB sky130_fd_sc_hd__fill_2
XFILLER_4_43 VSUBS VSUBS _999_/VPB _999_/VPB sky130_fd_sc_hd__decap_12
XFILLER_4_87 VSUBS VSUBS _999_/VPB _999_/VPB sky130_fd_sc_hd__decap_3
XTAP_TAPCELL_ROW_13_85 VSUBS _999_/VPB sky130_fd_sc_hd__tapvpwrvgnd_1
XTAP_TAPCELL_ROW_56_347 VSUBS _999_/VPB sky130_fd_sc_hd__tapvpwrvgnd_1
XFILLER_14_205 VSUBS VSUBS _999_/VPB _999_/VPB sky130_fd_sc_hd__decap_4
XFILLER_22_271 VSUBS VSUBS _999_/VPB _999_/VPB sky130_fd_sc_hd__fill_1
XTAP_TAPCELL_ROW_0_11 VSUBS _999_/VPB sky130_fd_sc_hd__tapvpwrvgnd_1
XFILLER_13_85 VSUBS VSUBS _999_/VPB _999_/VPB sky130_fd_sc_hd__decap_12
XTAP_TAPCELL_ROW_9_64 VSUBS _999_/VPB sky130_fd_sc_hd__tapvpwrvgnd_1
XFILLER_60_355 VSUBS VSUBS _999_/VPB _999_/VPB sky130_fd_sc_hd__decap_12
X_517_ _944_/Q _976_/Q VSUBS VSUBS _999_/VPB _999_/VPB _518_/B sky130_fd_sc_hd__nand2b_1
X_448_ CRC_ERROR VSUBS VSUBS _999_/VPB _999_/VPB _538_/A sky130_fd_sc_hd__clkinv_1
XFILLER_9_264 VSUBS VSUBS _999_/VPB _999_/VPB sky130_fd_sc_hd__decap_12
XFILLER_13_293 VSUBS VSUBS _999_/VPB _999_/VPB sky130_fd_sc_hd__decap_6
XTAP_TAPCELL_ROW_53_328 VSUBS _999_/VPB sky130_fd_sc_hd__tapvpwrvgnd_1
XTAP_TAPCELL_ROW_61_383 VSUBS _999_/VPB sky130_fd_sc_hd__tapvpwrvgnd_1
XTAP_TAPCELL_ROW_61_372 VSUBS _999_/VPB sky130_fd_sc_hd__tapvpwrvgnd_1
Xclkload6 _978_/CLK VSUBS VSUBS _999_/VPB _999_/VPB clkload6/Y sky130_fd_sc_hd__clkinvlp_4
XFILLER_59_48 VSUBS VSUBS _999_/VPB _999_/VPB sky130_fd_sc_hd__decap_12
XFILLER_46_127 VSUBS VSUBS _999_/VPB _999_/VPB sky130_fd_sc_hd__decap_12
XFILLER_19_308 VSUBS VSUBS _999_/VPB _999_/VPB sky130_fd_sc_hd__decap_12
XFILLER_61_119 VSUBS VSUBS _999_/VPB _999_/VPB sky130_fd_sc_hd__fill_1
XFILLER_54_171 VSUBS VSUBS _999_/VPB _999_/VPB sky130_fd_sc_hd__fill_1
XFILLER_6_267 VSUBS VSUBS _999_/VPB _999_/VPB sky130_fd_sc_hd__decap_3
XFILLER_6_223 VSUBS VSUBS _999_/VPB _999_/VPB sky130_fd_sc_hd__decap_12
X_997_ VSUBS VSUBS _999_/VPB _999_/VPB _997_/HI STATUS_REG[13] sky130_fd_sc_hd__conb_1
XFILLER_6_289 VSUBS VSUBS _999_/VPB _999_/VPB sky130_fd_sc_hd__decap_12
XFILLER_18_341 VSUBS VSUBS _999_/VPB _999_/VPB sky130_fd_sc_hd__decap_3
XFILLER_18_352 VSUBS VSUBS _999_/VPB _999_/VPB sky130_fd_sc_hd__decap_12
XFILLER_60_163 VSUBS VSUBS _999_/VPB _999_/VPB sky130_fd_sc_hd__decap_12
XTAP_TAPCELL_ROW_50_309 VSUBS _999_/VPB sky130_fd_sc_hd__tapvpwrvgnd_1
XFILLER_45_193 VSUBS VSUBS _999_/VPB _999_/VPB sky130_fd_sc_hd__decap_12
XFILLER_53_0 VSUBS VSUBS _999_/VPB _999_/VPB sky130_fd_sc_hd__decap_12
XFILLER_28_127 VSUBS VSUBS _999_/VPB _999_/VPB sky130_fd_sc_hd__decap_6
XFILLER_36_182 VSUBS VSUBS _999_/VPB _999_/VPB sky130_fd_sc_hd__decap_6
XFILLER_24_300 VSUBS VSUBS _999_/VPB _999_/VPB sky130_fd_sc_hd__decap_12
XFILLER_24_355 VSUBS VSUBS _999_/VPB _999_/VPB sky130_fd_sc_hd__decap_12
XFILLER_51_185 VSUBS VSUBS _999_/VPB _999_/VPB sky130_fd_sc_hd__decap_12
X_920_ _959_/CLK _920_/D VSUBS VSUBS _999_/VPB _999_/VPB _920_/Q sky130_fd_sc_hd__dfxtp_1
Xspare_dff_0 spare_dff_0/CLK spare_dff_0/D spare_dff_0/RESET_B VSUBS VSUBS _999_/VPB
+ _999_/VPB spare_dff_0/Q sky130_fd_sc_hd__dfrtp_1
X_851_ _833_/Y _849_/Y _850_/Y VSUBS VSUBS _999_/VPB _999_/VPB _968_/D sky130_fd_sc_hd__a21oi_1
XFILLER_3_248 VSUBS VSUBS _999_/VPB _999_/VPB sky130_fd_sc_hd__decap_8
XFILLER_10_31 VSUBS VSUBS _999_/VPB _999_/VPB sky130_fd_sc_hd__decap_12
X_782_ _939_/Q _788_/A _765_/Y _781_/Y VSUBS VSUBS _999_/VPB _999_/VPB _783_/B sky130_fd_sc_hd__a22oi_1
XFILLER_19_73 VSUBS VSUBS _999_/VPB _999_/VPB sky130_fd_sc_hd__decap_12
XFILLER_42_163 VSUBS VSUBS _999_/VPB _999_/VPB sky130_fd_sc_hd__decap_8
XFILLER_35_61 VSUBS VSUBS _999_/VPB _999_/VPB sky130_fd_sc_hd__decap_12
XFILLER_30_303 VSUBS VSUBS _999_/VPB _999_/VPB sky130_fd_sc_hd__decap_12
XTAP_TAPCELL_ROW_6_43 VSUBS _999_/VPB sky130_fd_sc_hd__tapvpwrvgnd_1
XFILLER_27_193 VSUBS VSUBS _999_/VPB _999_/VPB sky130_fd_sc_hd__decap_12
XFILLER_21_325 VSUBS VSUBS _999_/VPB _999_/VPB sky130_fd_sc_hd__decap_12
XFILLER_56_211 VSUBS VSUBS _999_/VPB _999_/VPB sky130_fd_sc_hd__decap_12
XFILLER_8_307 VSUBS VSUBS _999_/VPB _999_/VPB sky130_fd_sc_hd__decap_12
XFILLER_12_325 VSUBS VSUBS _999_/VPB _999_/VPB sky130_fd_sc_hd__decap_4
XFILLER_24_163 VSUBS VSUBS _999_/VPB _999_/VPB sky130_fd_sc_hd__decap_12
XFILLER_21_85 VSUBS VSUBS _999_/VPB _999_/VPB sky130_fd_sc_hd__decap_12
X_903_ _978_/CLK _903_/D VSUBS VSUBS _999_/VPB _999_/VPB LAST_CMD[3] sky130_fd_sc_hd__dfxtp_1
X_834_ _881_/Q ESPI_CS_N _861_/B VSUBS VSUBS _999_/VPB _999_/VPB _836_/A sky130_fd_sc_hd__nor3_1
XFILLER_47_277 VSUBS VSUBS _999_/VPB _999_/VPB sky130_fd_sc_hd__decap_12
X_696_ _924_/Q _690_/Y _978_/Q VSUBS VSUBS _999_/VPB _999_/VPB _697_/B sky130_fd_sc_hd__o21ai_0
X_765_ _975_/Q _765_/B _765_/C VSUBS VSUBS _999_/VPB _999_/VPB _765_/Y sky130_fd_sc_hd__nor3_1
XFILLER_38_211 VSUBS VSUBS _999_/VPB _999_/VPB sky130_fd_sc_hd__decap_12
XFILLER_16_0 VSUBS VSUBS _999_/VPB _999_/VPB sky130_fd_sc_hd__decap_12
XFILLER_53_236 VSUBS VSUBS _999_/VPB _999_/VPB sky130_fd_sc_hd__decap_4
XTAP_TAPCELL_ROW_48_294 VSUBS _999_/VPB sky130_fd_sc_hd__tapvpwrvgnd_1
XFILLER_21_133 VSUBS VSUBS _999_/VPB _999_/VPB sky130_fd_sc_hd__decap_6
XTAP_TAPCELL_ROW_31_194 VSUBS _999_/VPB sky130_fd_sc_hd__tapvpwrvgnd_1
XFILLER_21_177 VSUBS VSUBS _999_/VPB _999_/VPB sky130_fd_sc_hd__decap_3
XFILLER_44_203 VSUBS VSUBS _999_/VPB _999_/VPB sky130_fd_sc_hd__decap_6
X_481_ LAST_CMD[3] LAST_CMD[2] LAST_CMD[1] CH_VW_READY VSUBS VSUBS _999_/VPB _999_/VPB
+ _481_/Y sky130_fd_sc_hd__nor4b_1
X_550_ CRC_ERROR _979_/Q _554_/A _549_/Y VSUBS VSUBS _999_/VPB _999_/VPB _551_/B sky130_fd_sc_hd__a22oi_1
XFILLER_29_277 VSUBS VSUBS _999_/VPB _999_/VPB sky130_fd_sc_hd__decap_12
XFILLER_52_291 VSUBS VSUBS _999_/VPB _999_/VPB sky130_fd_sc_hd__decap_3
XFILLER_8_115 VSUBS VSUBS _999_/VPB _999_/VPB sky130_fd_sc_hd__decap_12
XFILLER_12_199 VSUBS VSUBS _999_/VPB _999_/VPB sky130_fd_sc_hd__decap_8
X_817_ _956_/Q _803_/Y _459_/B VSUBS VSUBS _999_/VPB _999_/VPB _818_/B sky130_fd_sc_hd__o21ai_0
XFILLER_50_206 VSUBS VSUBS _999_/VPB _999_/VPB sky130_fd_sc_hd__decap_4
X_748_ _748_/A _748_/B VSUBS VSUBS _999_/VPB _999_/VPB _755_/A sky130_fd_sc_hd__xor2_1
X_679_ _923_/Q _922_/Q _921_/Q _920_/Q VSUBS VSUBS _999_/VPB _999_/VPB _690_/B sky130_fd_sc_hd__nor4_1
XFILLER_41_206 VSUBS VSUBS _999_/VPB _999_/VPB sky130_fd_sc_hd__decap_8
XFILLER_26_269 VSUBS VSUBS _999_/VPB _999_/VPB sky130_fd_sc_hd__fill_1
XFILLER_1_313 VSUBS VSUBS _999_/VPB _999_/VPB sky130_fd_sc_hd__decap_12
XFILLER_57_361 VSUBS VSUBS _999_/VPB _999_/VPB sky130_fd_sc_hd__decap_8
X_602_ _982_/Q _977_/Q VSUBS VSUBS _999_/VPB _999_/VPB _602_/Y sky130_fd_sc_hd__nor2_1
XFILLER_1_357 VSUBS VSUBS _999_/VPB _999_/VPB sky130_fd_sc_hd__decap_3
X_533_ _950_/Q _531_/B _945_/Q VSUBS VSUBS _999_/VPB _999_/VPB _534_/B sky130_fd_sc_hd__o21ai_0
XFILLER_32_239 VSUBS VSUBS _999_/VPB _999_/VPB sky130_fd_sc_hd__decap_12
X_464_ _587_/C _464_/B VSUBS VSUBS _999_/VPB _999_/VPB _559_/A sky130_fd_sc_hd__nand2_1
XFILLER_27_73 VSUBS VSUBS _999_/VPB _999_/VPB sky130_fd_sc_hd__decap_12
XFILLER_43_61 VSUBS VSUBS _999_/VPB _999_/VPB sky130_fd_sc_hd__decap_12
XFILLER_40_250 VSUBS VSUBS _999_/VPB _999_/VPB sky130_fd_sc_hd__decap_12
XFILLER_4_151 VSUBS VSUBS _999_/VPB _999_/VPB sky130_fd_sc_hd__decap_12
XFILLER_4_55 VSUBS VSUBS _999_/VPB _999_/VPB sky130_fd_sc_hd__decap_12
XFILLER_31_261 VSUBS VSUBS _999_/VPB _999_/VPB sky130_fd_sc_hd__decap_8
Xclkbuf_3_2__f_clk clkbuf_0_clk/X VSUBS VSUBS _999_/VPB _999_/VPB _969_/CLK sky130_fd_sc_hd__clkbuf_16
XFILLER_58_103 VSUBS VSUBS _999_/VPB _999_/VPB sky130_fd_sc_hd__decap_12
XFILLER_39_361 VSUBS VSUBS _999_/VPB _999_/VPB sky130_fd_sc_hd__decap_8
XTAP_TAPCELL_ROW_13_86 VSUBS _999_/VPB sky130_fd_sc_hd__tapvpwrvgnd_1
XFILLER_54_331 VSUBS VSUBS _999_/VPB _999_/VPB sky130_fd_sc_hd__decap_12
XFILLER_13_97 VSUBS VSUBS _999_/VPB _999_/VPB sky130_fd_sc_hd__decap_12
XFILLER_1_121 VSUBS VSUBS _999_/VPB _999_/VPB sky130_fd_sc_hd__decap_12
XTAP_TAPCELL_ROW_9_65 VSUBS _999_/VPB sky130_fd_sc_hd__tapvpwrvgnd_1
XFILLER_60_367 VSUBS VSUBS _999_/VPB _999_/VPB sky130_fd_sc_hd__fill_2
X_447_ _908_/Q VSUBS VSUBS _999_/VPB _999_/VPB _447_/Y sky130_fd_sc_hd__clkinv_1
X_516_ _516_/A _765_/B VSUBS VSUBS _999_/VPB _999_/VPB _520_/A sky130_fd_sc_hd__nand2_1
XFILLER_9_276 VSUBS VSUBS _999_/VPB _999_/VPB sky130_fd_sc_hd__decap_8
XFILLER_55_117 VSUBS VSUBS _999_/VPB _999_/VPB sky130_fd_sc_hd__decap_3
XTAP_TAPCELL_ROW_53_329 VSUBS _999_/VPB sky130_fd_sc_hd__tapvpwrvgnd_1
XFILLER_36_331 VSUBS VSUBS _999_/VPB _999_/VPB sky130_fd_sc_hd__decap_8
XTAP_TAPCELL_ROW_61_373 VSUBS _999_/VPB sky130_fd_sc_hd__tapvpwrvgnd_1
XFILLER_46_139 VSUBS VSUBS _999_/VPB _999_/VPB sky130_fd_sc_hd__decap_4
XFILLER_42_356 VSUBS VSUBS _999_/VPB _999_/VPB sky130_fd_sc_hd__decap_12
XFILLER_42_323 VSUBS VSUBS _999_/VPB _999_/VPB sky130_fd_sc_hd__decap_6
XFILLER_6_235 VSUBS VSUBS _999_/VPB _999_/VPB sky130_fd_sc_hd__decap_12
XFILLER_10_242 VSUBS VSUBS _999_/VPB _999_/VPB sky130_fd_sc_hd__decap_12
X_996_ VSUBS VSUBS _999_/VPB _999_/VPB _996_/HI STATUS_REG[12] sky130_fd_sc_hd__conb_1
XFILLER_1_12 VSUBS VSUBS _999_/VPB _999_/VPB sky130_fd_sc_hd__decap_12
XFILLER_37_117 VSUBS VSUBS _999_/VPB _999_/VPB sky130_fd_sc_hd__decap_3
XFILLER_33_301 VSUBS VSUBS _999_/VPB _999_/VPB sky130_fd_sc_hd__decap_12
XFILLER_18_331 VSUBS VSUBS _999_/VPB _999_/VPB sky130_fd_sc_hd__fill_2
XFILLER_18_364 VSUBS VSUBS _999_/VPB _999_/VPB sky130_fd_sc_hd__decap_4
XFILLER_60_175 VSUBS VSUBS _999_/VPB _999_/VPB sky130_fd_sc_hd__decap_12
XFILLER_46_0 VSUBS VSUBS _999_/VPB _999_/VPB sky130_fd_sc_hd__decap_12
XFILLER_51_197 VSUBS VSUBS _999_/VPB _999_/VPB sky130_fd_sc_hd__decap_3
XFILLER_51_153 VSUBS VSUBS _999_/VPB _999_/VPB sky130_fd_sc_hd__decap_12
XFILLER_24_312 VSUBS VSUBS _999_/VPB _999_/VPB sky130_fd_sc_hd__decap_12
XFILLER_24_367 VSUBS VSUBS _999_/VPB _999_/VPB sky130_fd_sc_hd__fill_2
XFILLER_59_231 VSUBS VSUBS _999_/VPB _999_/VPB sky130_fd_sc_hd__decap_3
X_850_ _968_/Q _833_/Y _587_/C VSUBS VSUBS _999_/VPB _999_/VPB _850_/Y sky130_fd_sc_hd__o21ai_0
X_781_ _941_/Q _781_/B VSUBS VSUBS _999_/VPB _999_/VPB _781_/Y sky130_fd_sc_hd__xnor2_1
XFILLER_10_43 VSUBS VSUBS _999_/VPB _999_/VPB sky130_fd_sc_hd__decap_12
XFILLER_10_87 VSUBS VSUBS _999_/VPB _999_/VPB sky130_fd_sc_hd__decap_3
XFILLER_15_301 VSUBS VSUBS _999_/VPB _999_/VPB sky130_fd_sc_hd__fill_2
XFILLER_19_85 VSUBS VSUBS _999_/VPB _999_/VPB sky130_fd_sc_hd__decap_12
XFILLER_19_117 VSUBS VSUBS _999_/VPB _999_/VPB sky130_fd_sc_hd__decap_3
XFILLER_51_61 VSUBS VSUBS _999_/VPB _999_/VPB sky130_fd_sc_hd__decap_12
XFILLER_35_73 VSUBS VSUBS _999_/VPB _999_/VPB sky130_fd_sc_hd__decap_12
XFILLER_30_315 VSUBS VSUBS _999_/VPB _999_/VPB sky130_fd_sc_hd__decap_12
XTAP_TAPCELL_ROW_6_44 VSUBS _999_/VPB sky130_fd_sc_hd__tapvpwrvgnd_1
X_979_ _981_/CLK _979_/D VSUBS VSUBS _999_/VPB _999_/VPB _979_/Q sky130_fd_sc_hd__dfxtp_1
XFILLER_33_197 VSUBS VSUBS _999_/VPB _999_/VPB sky130_fd_sc_hd__decap_12
XFILLER_21_337 VSUBS VSUBS _999_/VPB _999_/VPB sky130_fd_sc_hd__decap_6
XFILLER_25_109 VSUBS VSUBS _999_/VPB _999_/VPB sky130_fd_sc_hd__decap_8
XFILLER_56_267 VSUBS VSUBS _999_/VPB _999_/VPB sky130_fd_sc_hd__decap_3
XFILLER_56_223 VSUBS VSUBS _999_/VPB _999_/VPB sky130_fd_sc_hd__decap_4
XFILLER_8_319 VSUBS VSUBS _999_/VPB _999_/VPB sky130_fd_sc_hd__decap_8
XFILLER_24_175 VSUBS VSUBS _999_/VPB _999_/VPB sky130_fd_sc_hd__decap_12
XFILLER_21_97 VSUBS VSUBS _999_/VPB _999_/VPB sky130_fd_sc_hd__decap_12
X_902_ _978_/CLK _902_/D VSUBS VSUBS _999_/VPB _999_/VPB LAST_CMD[2] sky130_fd_sc_hd__dfxtp_1
X_833_ _861_/B _859_/B ESPI_CS_N VSUBS VSUBS _999_/VPB _999_/VPB _833_/Y sky130_fd_sc_hd__a21oi_1
X_764_ _578_/A _578_/B _627_/B _977_/Q _627_/Y VSUBS VSUBS _999_/VPB _999_/VPB _788_/A
+ sky130_fd_sc_hd__o221ai_1
XFILLER_47_289 VSUBS VSUBS _999_/VPB _999_/VPB sky130_fd_sc_hd__decap_8
X_695_ _723_/A _695_/B _695_/C VSUBS VSUBS _999_/VPB _999_/VPB _917_/D sky130_fd_sc_hd__nor3_1
XFILLER_15_197 VSUBS VSUBS _999_/VPB _999_/VPB sky130_fd_sc_hd__decap_12
XTAP_TAPCELL_ROW_48_295 VSUBS _999_/VPB sky130_fd_sc_hd__tapvpwrvgnd_1
XFILLER_38_223 VSUBS VSUBS _999_/VPB _999_/VPB sky130_fd_sc_hd__decap_12
XFILLER_21_156 VSUBS VSUBS _999_/VPB _999_/VPB sky130_fd_sc_hd__decap_8
XTAP_TAPCELL_ROW_31_195 VSUBS _999_/VPB sky130_fd_sc_hd__tapvpwrvgnd_1
XFILLER_29_201 VSUBS VSUBS _999_/VPB _999_/VPB sky130_fd_sc_hd__decap_12
XTAP_TAPCELL_ROW_39_240 VSUBS _999_/VPB sky130_fd_sc_hd__tapvpwrvgnd_1
X_480_ LAST_CMD[3] LAST_CMD[2] LAST_CMD[1] CH_OOB_READY VSUBS VSUBS _999_/VPB _999_/VPB
+ _480_/Y sky130_fd_sc_hd__nor4bb_1
XFILLER_16_31 VSUBS VSUBS _999_/VPB _999_/VPB sky130_fd_sc_hd__decap_12
XFILLER_29_289 VSUBS VSUBS _999_/VPB _999_/VPB sky130_fd_sc_hd__decap_3
XFILLER_8_127 VSUBS VSUBS _999_/VPB _999_/VPB sky130_fd_sc_hd__decap_12
XTAP_TAPCELL_ROW_22_140 VSUBS _999_/VPB sky130_fd_sc_hd__tapvpwrvgnd_1
X_816_ _957_/Q _822_/B VSUBS VSUBS _999_/VPB _999_/VPB _818_/A sky130_fd_sc_hd__nor2_1
X_747_ _748_/B VSUBS VSUBS _999_/VPB _999_/VPB _747_/Y sky130_fd_sc_hd__clkinv_1
XFILLER_35_226 VSUBS VSUBS _999_/VPB _999_/VPB sky130_fd_sc_hd__decap_6
XTAP_TAPCELL_ROW_45_276 VSUBS _999_/VPB sky130_fd_sc_hd__tapvpwrvgnd_1
X_678_ _440_/Y _662_/Y _677_/Y VSUBS VSUBS _999_/VPB _999_/VPB _915_/D sky130_fd_sc_hd__a21oi_1
XFILLER_1_325 VSUBS VSUBS _999_/VPB _999_/VPB sky130_fd_sc_hd__decap_12
X_601_ _601_/A _601_/B VSUBS VSUBS _999_/VPB _999_/VPB _890_/D sky130_fd_sc_hd__nor2_1
X_532_ _439_/Y _946_/Q _947_/Q VSUBS VSUBS _999_/VPB _999_/VPB _534_/A sky130_fd_sc_hd__o21ai_0
XFILLER_43_73 VSUBS VSUBS _999_/VPB _999_/VPB sky130_fd_sc_hd__decap_12
XFILLER_43_40 VSUBS VSUBS _999_/VPB _999_/VPB sky130_fd_sc_hd__decap_12
XFILLER_40_262 VSUBS VSUBS _999_/VPB _999_/VPB sky130_fd_sc_hd__decap_4
X_463_ _975_/Q _828_/A VSUBS VSUBS _999_/VPB _999_/VPB _516_/A sky130_fd_sc_hd__nor2_1
XFILLER_25_292 VSUBS VSUBS _999_/VPB _999_/VPB sky130_fd_sc_hd__decap_8
XFILLER_27_85 VSUBS VSUBS _999_/VPB _999_/VPB sky130_fd_sc_hd__decap_12
XFILLER_4_163 VSUBS VSUBS _999_/VPB _999_/VPB sky130_fd_sc_hd__decap_12
XFILLER_4_67 VSUBS VSUBS _999_/VPB _999_/VPB sky130_fd_sc_hd__decap_12
XFILLER_4_12 VSUBS VSUBS _999_/VPB _999_/VPB sky130_fd_sc_hd__decap_12
XFILLER_58_115 VSUBS VSUBS _999_/VPB _999_/VPB sky130_fd_sc_hd__decap_12
XTAP_TAPCELL_ROW_13_87 VSUBS _999_/VPB sky130_fd_sc_hd__tapvpwrvgnd_1
XFILLER_1_133 VSUBS VSUBS _999_/VPB _999_/VPB sky130_fd_sc_hd__decap_12
XFILLER_1_177 VSUBS VSUBS _999_/VPB _999_/VPB sky130_fd_sc_hd__decap_3
X_515_ _578_/A _578_/B VSUBS VSUBS _999_/VPB _999_/VPB _765_/B sky130_fd_sc_hd__nor2_1
X_446_ _909_/Q VSUBS VSUBS _999_/VPB _999_/VPB _446_/Y sky130_fd_sc_hd__clkinv_1
XFILLER_9_222 VSUBS VSUBS _999_/VPB _999_/VPB sky130_fd_sc_hd__fill_1
XFILLER_51_335 VSUBS VSUBS _999_/VPB _999_/VPB sky130_fd_sc_hd__fill_1
XFILLER_48_181 VSUBS VSUBS _999_/VPB _999_/VPB sky130_fd_sc_hd__fill_2
XTAP_TAPCELL_ROW_61_374 VSUBS _999_/VPB sky130_fd_sc_hd__tapvpwrvgnd_1
XFILLER_54_151 VSUBS VSUBS _999_/VPB _999_/VPB sky130_fd_sc_hd__decap_12
XFILLER_39_181 VSUBS VSUBS _999_/VPB _999_/VPB sky130_fd_sc_hd__decap_12
XFILLER_27_343 VSUBS VSUBS _999_/VPB _999_/VPB sky130_fd_sc_hd__fill_1
XFILLER_42_368 VSUBS VSUBS _999_/VPB _999_/VPB sky130_fd_sc_hd__fill_1
XFILLER_10_232 VSUBS VSUBS _999_/VPB _999_/VPB sky130_fd_sc_hd__decap_3
XFILLER_24_31 VSUBS VSUBS _999_/VPB _999_/VPB sky130_fd_sc_hd__decap_12
XFILLER_6_247 VSUBS VSUBS _999_/VPB _999_/VPB sky130_fd_sc_hd__decap_12
XFILLER_6_0 VSUBS VSUBS _999_/VPB _999_/VPB sky130_fd_sc_hd__decap_12
XFILLER_10_254 VSUBS VSUBS _999_/VPB _999_/VPB sky130_fd_sc_hd__decap_3
XFILLER_49_61 VSUBS VSUBS _999_/VPB _999_/VPB sky130_fd_sc_hd__decap_12
XFILLER_1_24 VSUBS VSUBS _999_/VPB _999_/VPB sky130_fd_sc_hd__decap_12
X_995_ VSUBS VSUBS _999_/VPB _999_/VPB _995_/HI STATUS_REG[11] sky130_fd_sc_hd__conb_1
XFILLER_33_357 VSUBS VSUBS _999_/VPB _999_/VPB sky130_fd_sc_hd__decap_3
XFILLER_33_313 VSUBS VSUBS _999_/VPB _999_/VPB sky130_fd_sc_hd__decap_8
XFILLER_60_187 VSUBS VSUBS _999_/VPB _999_/VPB sky130_fd_sc_hd__decap_12
XFILLER_39_0 VSUBS VSUBS _999_/VPB _999_/VPB sky130_fd_sc_hd__decap_12
XTAP_TAPCELL_ROW_10_66 VSUBS _999_/VPB sky130_fd_sc_hd__tapvpwrvgnd_1
XFILLER_51_165 VSUBS VSUBS _999_/VPB _999_/VPB sky130_fd_sc_hd__decap_8
XFILLER_51_121 VSUBS VSUBS _999_/VPB _999_/VPB sky130_fd_sc_hd__decap_12
XFILLER_24_324 VSUBS VSUBS _999_/VPB _999_/VPB sky130_fd_sc_hd__decap_6
XFILLER_3_239 VSUBS VSUBS _999_/VPB _999_/VPB sky130_fd_sc_hd__fill_1
XFILLER_10_55 VSUBS VSUBS _999_/VPB _999_/VPB sky130_fd_sc_hd__decap_12
X_780_ _828_/A _780_/B VSUBS VSUBS _999_/VPB _999_/VPB _938_/D sky130_fd_sc_hd__nor2_1
XFILLER_35_85 VSUBS VSUBS _999_/VPB _999_/VPB sky130_fd_sc_hd__decap_12
XTAP_TAPCELL_ROW_6_45 VSUBS _999_/VPB sky130_fd_sc_hd__tapvpwrvgnd_1
XFILLER_19_97 VSUBS VSUBS _999_/VPB _999_/VPB sky130_fd_sc_hd__decap_12
XFILLER_51_73 VSUBS VSUBS _999_/VPB _999_/VPB sky130_fd_sc_hd__decap_12
XFILLER_30_327 VSUBS VSUBS _999_/VPB _999_/VPB sky130_fd_sc_hd__decap_3
XFILLER_2_261 VSUBS VSUBS _999_/VPB _999_/VPB sky130_fd_sc_hd__fill_2
X_978_ _978_/CLK _978_/D VSUBS VSUBS _999_/VPB _999_/VPB _978_/Q sky130_fd_sc_hd__dfxtp_1
XFILLER_18_151 VSUBS VSUBS _999_/VPB _999_/VPB sky130_fd_sc_hd__decap_12
XFILLER_33_121 VSUBS VSUBS _999_/VPB _999_/VPB sky130_fd_sc_hd__decap_12
XFILLER_18_195 VSUBS VSUBS _999_/VPB _999_/VPB sky130_fd_sc_hd__fill_1
XFILLER_0_209 VSUBS VSUBS _999_/VPB _999_/VPB sky130_fd_sc_hd__fill_1
XFILLER_12_305 VSUBS VSUBS _999_/VPB _999_/VPB sky130_fd_sc_hd__decap_12
XFILLER_24_187 VSUBS VSUBS _999_/VPB _999_/VPB sky130_fd_sc_hd__decap_8
XFILLER_24_198 VSUBS VSUBS _999_/VPB _999_/VPB sky130_fd_sc_hd__decap_12
X_901_ _959_/CLK _901_/D VSUBS VSUBS _999_/VPB _999_/VPB LAST_CMD[1] sky130_fd_sc_hd__dfxtp_1
XFILLER_47_202 VSUBS VSUBS _999_/VPB _999_/VPB sky130_fd_sc_hd__decap_12
X_763_ _758_/Y _762_/Y _828_/A VSUBS VSUBS _999_/VPB _999_/VPB _935_/D sky130_fd_sc_hd__a21oi_1
X_694_ _703_/A _692_/B CH_ENABLE[2] VSUBS VSUBS _999_/VPB _999_/VPB _695_/C sky130_fd_sc_hd__a21oi_1
X_832_ _975_/Q ESPI_BIT_TICK VSUBS VSUBS _999_/VPB _999_/VPB _859_/B sky130_fd_sc_hd__nand2_1
XFILLER_30_135 VSUBS VSUBS _999_/VPB _999_/VPB sky130_fd_sc_hd__fill_2
XFILLER_15_121 VSUBS VSUBS _999_/VPB _999_/VPB sky130_fd_sc_hd__decap_6
XTAP_TAPCELL_ROW_25_160 VSUBS _999_/VPB sky130_fd_sc_hd__tapvpwrvgnd_1
XFILLER_7_12 VSUBS VSUBS _999_/VPB _999_/VPB sky130_fd_sc_hd__decap_12
XTAP_TAPCELL_ROW_48_296 VSUBS _999_/VPB sky130_fd_sc_hd__tapvpwrvgnd_1
XFILLER_38_279 VSUBS VSUBS _999_/VPB _999_/VPB sky130_fd_sc_hd__decap_12
XFILLER_38_235 VSUBS VSUBS _999_/VPB _999_/VPB sky130_fd_sc_hd__decap_12
XFILLER_61_271 VSUBS VSUBS _999_/VPB _999_/VPB sky130_fd_sc_hd__decap_12
XFILLER_21_168 VSUBS VSUBS _999_/VPB _999_/VPB sky130_fd_sc_hd__fill_1
XTAP_TAPCELL_ROW_31_196 VSUBS _999_/VPB sky130_fd_sc_hd__tapvpwrvgnd_1
XTAP_TAPCELL_ROW_39_241 VSUBS _999_/VPB sky130_fd_sc_hd__tapvpwrvgnd_1
XFILLER_29_213 VSUBS VSUBS _999_/VPB _999_/VPB sky130_fd_sc_hd__decap_12
XFILLER_52_271 VSUBS VSUBS _999_/VPB _999_/VPB sky130_fd_sc_hd__decap_12
XFILLER_37_290 VSUBS VSUBS _999_/VPB _999_/VPB sky130_fd_sc_hd__decap_8
XFILLER_16_43 VSUBS VSUBS _999_/VPB _999_/VPB sky130_fd_sc_hd__decap_12
XFILLER_16_87 VSUBS VSUBS _999_/VPB _999_/VPB sky130_fd_sc_hd__decap_3
XFILLER_32_31 VSUBS VSUBS _999_/VPB _999_/VPB sky130_fd_sc_hd__decap_12
XTAP_TAPCELL_ROW_3_24 VSUBS _999_/VPB sky130_fd_sc_hd__tapvpwrvgnd_1
XFILLER_8_139 VSUBS VSUBS _999_/VPB _999_/VPB sky130_fd_sc_hd__decap_8
XTAP_TAPCELL_ROW_22_141 VSUBS _999_/VPB sky130_fd_sc_hd__tapvpwrvgnd_1
X_815_ _815_/A _815_/B VSUBS VSUBS _999_/VPB _999_/VPB _956_/D sky130_fd_sc_hd__nor2_1
XFILLER_57_61 VSUBS VSUBS _999_/VPB _999_/VPB sky130_fd_sc_hd__decap_12
X_746_ _753_/A _746_/B VSUBS VSUBS _999_/VPB _999_/VPB _748_/B sky130_fd_sc_hd__xnor2_1
X_677_ _952_/Q _662_/Y _459_/B VSUBS VSUBS _999_/VPB _999_/VPB _677_/Y sky130_fd_sc_hd__o21ai_0
XTAP_TAPCELL_ROW_45_277 VSUBS _999_/VPB sky130_fd_sc_hd__tapvpwrvgnd_1
XFILLER_21_0 VSUBS VSUBS _999_/VPB _999_/VPB sky130_fd_sc_hd__decap_12
XTAP_TAPCELL_ROW_36_222 VSUBS _999_/VPB sky130_fd_sc_hd__tapvpwrvgnd_1
XFILLER_34_271 VSUBS VSUBS _999_/VPB _999_/VPB sky130_fd_sc_hd__decap_8
XFILLER_34_260 VSUBS VSUBS _999_/VPB _999_/VPB sky130_fd_sc_hd__decap_8
XFILLER_5_109 VSUBS VSUBS _999_/VPB _999_/VPB sky130_fd_sc_hd__decap_8
XFILLER_1_337 VSUBS VSUBS _999_/VPB _999_/VPB sky130_fd_sc_hd__decap_12
X_531_ _945_/Q _531_/B VSUBS VSUBS _999_/VPB _999_/VPB _535_/B sky130_fd_sc_hd__nor2_1
XFILLER_17_227 VSUBS VSUBS _999_/VPB _999_/VPB sky130_fd_sc_hd__fill_1
X_600_ _518_/Y _599_/Y CRC_ERROR _459_/B VSUBS VSUBS _999_/VPB _999_/VPB _601_/B sky130_fd_sc_hd__a2bb2oi_1
XFILLER_43_85 VSUBS VSUBS _999_/VPB _999_/VPB sky130_fd_sc_hd__decap_12
XFILLER_43_52 VSUBS VSUBS _999_/VPB _999_/VPB sky130_fd_sc_hd__decap_8
XTAP_TAPCELL_ROW_42_258 VSUBS _999_/VPB sky130_fd_sc_hd__tapvpwrvgnd_1
X_462_ _975_/Q ESPI_CS_N VSUBS VSUBS _999_/VPB _999_/VPB _464_/B sky130_fd_sc_hd__nor2_1
XFILLER_27_97 VSUBS VSUBS _999_/VPB _999_/VPB sky130_fd_sc_hd__decap_12
XFILLER_4_175 VSUBS VSUBS _999_/VPB _999_/VPB sky130_fd_sc_hd__decap_12
XFILLER_4_24 VSUBS VSUBS _999_/VPB _999_/VPB sky130_fd_sc_hd__decap_6
XFILLER_4_79 VSUBS VSUBS _999_/VPB _999_/VPB sky130_fd_sc_hd__decap_8
X_729_ _753_/A _733_/A VSUBS VSUBS _999_/VPB _999_/VPB _729_/Y sky130_fd_sc_hd__xnor2_1
XFILLER_16_271 VSUBS VSUBS _999_/VPB _999_/VPB sky130_fd_sc_hd__decap_8
XTAP_TAPCELL_ROW_13_88 VSUBS _999_/VPB sky130_fd_sc_hd__tapvpwrvgnd_1
XFILLER_58_127 VSUBS VSUBS _999_/VPB _999_/VPB sky130_fd_sc_hd__decap_12
XFILLER_54_366 VSUBS VSUBS _999_/VPB _999_/VPB sky130_fd_sc_hd__decap_3
XFILLER_1_145 VSUBS VSUBS _999_/VPB _999_/VPB sky130_fd_sc_hd__decap_12
XFILLER_57_193 VSUBS VSUBS _999_/VPB _999_/VPB sky130_fd_sc_hd__fill_2
XFILLER_45_333 VSUBS VSUBS _999_/VPB _999_/VPB sky130_fd_sc_hd__fill_2
X_514_ _512_/Y _513_/Y _828_/A VSUBS VSUBS _999_/VPB _999_/VPB _977_/D sky130_fd_sc_hd__a21oi_1
X_445_ _910_/Q VSUBS VSUBS _999_/VPB _999_/VPB _445_/Y sky130_fd_sc_hd__clkinv_1
XFILLER_9_256 VSUBS VSUBS _999_/VPB _999_/VPB sky130_fd_sc_hd__fill_1
XTAP_TAPCELL_ROW_61_375 VSUBS _999_/VPB sky130_fd_sc_hd__tapvpwrvgnd_1
XFILLER_54_163 VSUBS VSUBS _999_/VPB _999_/VPB sky130_fd_sc_hd__decap_8
XFILLER_39_193 VSUBS VSUBS _999_/VPB _999_/VPB sky130_fd_sc_hd__decap_12
XFILLER_27_311 VSUBS VSUBS _999_/VPB _999_/VPB sky130_fd_sc_hd__decap_12
XTAP_TAPCELL_ROW_52_320 VSUBS _999_/VPB sky130_fd_sc_hd__tapvpwrvgnd_1
XFILLER_42_347 VSUBS VSUBS _999_/VPB _999_/VPB sky130_fd_sc_hd__fill_1
XFILLER_10_200 VSUBS VSUBS _999_/VPB _999_/VPB sky130_fd_sc_hd__decap_8
XFILLER_10_211 VSUBS VSUBS _999_/VPB _999_/VPB sky130_fd_sc_hd__decap_4
XFILLER_24_43 VSUBS VSUBS _999_/VPB _999_/VPB sky130_fd_sc_hd__decap_12
XFILLER_24_87 VSUBS VSUBS _999_/VPB _999_/VPB sky130_fd_sc_hd__decap_3
XFILLER_40_31 VSUBS VSUBS _999_/VPB _999_/VPB sky130_fd_sc_hd__decap_12
XFILLER_6_259 VSUBS VSUBS _999_/VPB _999_/VPB sky130_fd_sc_hd__decap_8
XFILLER_49_73 VSUBS VSUBS _999_/VPB _999_/VPB sky130_fd_sc_hd__decap_12
X_994_ VSUBS VSUBS _999_/VPB _999_/VPB _994_/HI STATUS_REG[10] sky130_fd_sc_hd__conb_1
XFILLER_1_36 VSUBS VSUBS _999_/VPB _999_/VPB sky130_fd_sc_hd__decap_12
XFILLER_60_199 VSUBS VSUBS _999_/VPB _999_/VPB sky130_fd_sc_hd__decap_8
XFILLER_36_196 VSUBS VSUBS _999_/VPB _999_/VPB sky130_fd_sc_hd__fill_1
XFILLER_36_163 VSUBS VSUBS _999_/VPB _999_/VPB sky130_fd_sc_hd__decap_3
XTAP_TAPCELL_ROW_10_67 VSUBS _999_/VPB sky130_fd_sc_hd__tapvpwrvgnd_1
XFILLER_51_133 VSUBS VSUBS _999_/VPB _999_/VPB sky130_fd_sc_hd__decap_12
XFILLER_10_12 VSUBS VSUBS _999_/VPB _999_/VPB sky130_fd_sc_hd__decap_12
XFILLER_10_67 VSUBS VSUBS _999_/VPB _999_/VPB sky130_fd_sc_hd__decap_12
XFILLER_59_244 VSUBS VSUBS _999_/VPB _999_/VPB sky130_fd_sc_hd__decap_12
XFILLER_59_211 VSUBS VSUBS _999_/VPB _999_/VPB sky130_fd_sc_hd__decap_12
XFILLER_42_144 VSUBS VSUBS _999_/VPB _999_/VPB sky130_fd_sc_hd__decap_6
XFILLER_35_97 VSUBS VSUBS _999_/VPB _999_/VPB sky130_fd_sc_hd__decap_12
XTAP_TAPCELL_ROW_6_46 VSUBS _999_/VPB sky130_fd_sc_hd__tapvpwrvgnd_1
XFILLER_27_141 VSUBS VSUBS _999_/VPB _999_/VPB sky130_fd_sc_hd__fill_1
XFILLER_51_85 VSUBS VSUBS _999_/VPB _999_/VPB sky130_fd_sc_hd__decap_12
X_977_ _981_/CLK _977_/D VSUBS VSUBS _999_/VPB _999_/VPB _977_/Q sky130_fd_sc_hd__dfxtp_1
XFILLER_18_163 VSUBS VSUBS _999_/VPB _999_/VPB sky130_fd_sc_hd__decap_12
XFILLER_33_177 VSUBS VSUBS _999_/VPB _999_/VPB sky130_fd_sc_hd__decap_3
XFILLER_33_133 VSUBS VSUBS _999_/VPB _999_/VPB sky130_fd_sc_hd__decap_12
XFILLER_51_0 VSUBS VSUBS _999_/VPB _999_/VPB sky130_fd_sc_hd__decap_12
XFILLER_56_247 VSUBS VSUBS _999_/VPB _999_/VPB sky130_fd_sc_hd__decap_12
XFILLER_12_317 VSUBS VSUBS _999_/VPB _999_/VPB sky130_fd_sc_hd__decap_4
X_831_ _975_/Q _880_/Q VSUBS VSUBS _999_/VPB _999_/VPB _861_/B sky130_fd_sc_hd__nand2b_1
X_900_ _970_/CLK _900_/D VSUBS VSUBS _999_/VPB _999_/VPB LAST_CMD[0] sky130_fd_sc_hd__dfxtp_1
XFILLER_47_214 VSUBS VSUBS _999_/VPB _999_/VPB sky130_fd_sc_hd__decap_12
X_762_ _759_/S _935_/Q VSUBS VSUBS _999_/VPB _999_/VPB _762_/Y sky130_fd_sc_hd__nand2b_1
X_693_ _945_/Q _978_/Q _692_/Y VSUBS VSUBS _999_/VPB _999_/VPB _695_/B sky130_fd_sc_hd__a21oi_1
XFILLER_30_103 VSUBS VSUBS _999_/VPB _999_/VPB sky130_fd_sc_hd__decap_12
XTAP_TAPCELL_ROW_25_161 VSUBS _999_/VPB sky130_fd_sc_hd__tapvpwrvgnd_1
XFILLER_7_24 VSUBS VSUBS _999_/VPB _999_/VPB sky130_fd_sc_hd__decap_12
XFILLER_11_361 VSUBS VSUBS _999_/VPB _999_/VPB sky130_fd_sc_hd__decap_8
XTAP_TAPCELL_ROW_48_297 VSUBS _999_/VPB sky130_fd_sc_hd__tapvpwrvgnd_1
XFILLER_38_269 VSUBS VSUBS _999_/VPB _999_/VPB sky130_fd_sc_hd__fill_1
XFILLER_38_247 VSUBS VSUBS _999_/VPB _999_/VPB sky130_fd_sc_hd__decap_12
XFILLER_61_283 VSUBS VSUBS _999_/VPB _999_/VPB sky130_fd_sc_hd__decap_12
XTAP_TAPCELL_ROW_31_197 VSUBS _999_/VPB sky130_fd_sc_hd__tapvpwrvgnd_1
XTAP_TAPCELL_ROW_0_0 VSUBS _999_/VPB sky130_fd_sc_hd__tapvpwrvgnd_1
XTAP_TAPCELL_ROW_39_242 VSUBS _999_/VPB sky130_fd_sc_hd__tapvpwrvgnd_1
XFILLER_29_225 VSUBS VSUBS _999_/VPB _999_/VPB sky130_fd_sc_hd__decap_12
XFILLER_52_283 VSUBS VSUBS _999_/VPB _999_/VPB sky130_fd_sc_hd__decap_8
XFILLER_12_103 VSUBS VSUBS _999_/VPB _999_/VPB sky130_fd_sc_hd__decap_12
XFILLER_12_147 VSUBS VSUBS _999_/VPB _999_/VPB sky130_fd_sc_hd__decap_3
XFILLER_16_55 VSUBS VSUBS _999_/VPB _999_/VPB sky130_fd_sc_hd__decap_12
XTAP_TAPCELL_ROW_22_142 VSUBS _999_/VPB sky130_fd_sc_hd__tapvpwrvgnd_1
XFILLER_32_87 VSUBS VSUBS _999_/VPB _999_/VPB sky130_fd_sc_hd__decap_3
XFILLER_32_43 VSUBS VSUBS _999_/VPB _999_/VPB sky130_fd_sc_hd__decap_12
XFILLER_4_313 VSUBS VSUBS _999_/VPB _999_/VPB sky130_fd_sc_hd__fill_1
XTAP_TAPCELL_ROW_3_25 VSUBS _999_/VPB sky130_fd_sc_hd__tapvpwrvgnd_1
X_814_ _955_/Q _803_/Y _459_/B VSUBS VSUBS _999_/VPB _999_/VPB _815_/B sky130_fd_sc_hd__o21ai_0
XFILLER_57_73 VSUBS VSUBS _999_/VPB _999_/VPB sky130_fd_sc_hd__decap_12
X_745_ _934_/Q _951_/Q VSUBS VSUBS _999_/VPB _999_/VPB _746_/B sky130_fd_sc_hd__xor2_1
XTAP_TAPCELL_ROW_45_278 VSUBS _999_/VPB sky130_fd_sc_hd__tapvpwrvgnd_1
X_676_ _441_/Y _662_/Y _675_/Y VSUBS VSUBS _999_/VPB _999_/VPB _914_/D sky130_fd_sc_hd__a21oi_1
XFILLER_35_239 VSUBS VSUBS _999_/VPB _999_/VPB sky130_fd_sc_hd__fill_1
XFILLER_58_309 VSUBS VSUBS _999_/VPB _999_/VPB sky130_fd_sc_hd__decap_4
XFILLER_14_0 VSUBS VSUBS _999_/VPB _999_/VPB sky130_fd_sc_hd__decap_12
XTAP_TAPCELL_ROW_36_223 VSUBS _999_/VPB sky130_fd_sc_hd__tapvpwrvgnd_1
XFILLER_19_291 VSUBS VSUBS _999_/VPB _999_/VPB sky130_fd_sc_hd__decap_8
XFILLER_1_349 VSUBS VSUBS _999_/VPB _999_/VPB sky130_fd_sc_hd__decap_8
X_530_ _946_/Q _949_/Q VSUBS VSUBS _999_/VPB _999_/VPB _531_/B sky130_fd_sc_hd__lpflow_isobufsrc_1
X_461_ _962_/Q _873_/B _873_/C VSUBS VSUBS _999_/VPB _999_/VPB _461_/X sky130_fd_sc_hd__and3_1
XFILLER_43_97 VSUBS VSUBS _999_/VPB _999_/VPB sky130_fd_sc_hd__decap_8
XTAP_TAPCELL_ROW_42_259 VSUBS _999_/VPB sky130_fd_sc_hd__tapvpwrvgnd_1
XFILLER_4_187 VSUBS VSUBS _999_/VPB _999_/VPB sky130_fd_sc_hd__decap_12
XFILLER_48_331 VSUBS VSUBS _999_/VPB _999_/VPB sky130_fd_sc_hd__decap_8
X_728_ _738_/A _753_/B VSUBS VSUBS _999_/VPB _999_/VPB _733_/A sky130_fd_sc_hd__xnor2_1
X_659_ LAST_CMD[7] _659_/B VSUBS VSUBS _999_/VPB _999_/VPB _661_/A sky130_fd_sc_hd__nor2_1
XTAP_TAPCELL_ROW_33_204 VSUBS _999_/VPB sky130_fd_sc_hd__tapvpwrvgnd_1
XFILLER_58_139 VSUBS VSUBS _999_/VPB _999_/VPB sky130_fd_sc_hd__decap_6
XTAP_TAPCELL_ROW_13_89 VSUBS _999_/VPB sky130_fd_sc_hd__tapvpwrvgnd_1
XFILLER_14_209 VSUBS VSUBS _999_/VPB _999_/VPB sky130_fd_sc_hd__fill_1
XFILLER_13_12 VSUBS VSUBS _999_/VPB _999_/VPB sky130_fd_sc_hd__decap_12
XFILLER_22_275 VSUBS VSUBS _999_/VPB _999_/VPB sky130_fd_sc_hd__decap_4
XFILLER_49_117 VSUBS VSUBS _999_/VPB _999_/VPB sky130_fd_sc_hd__decap_3
XFILLER_45_301 VSUBS VSUBS _999_/VPB _999_/VPB sky130_fd_sc_hd__fill_2
XFILLER_38_31 VSUBS VSUBS _999_/VPB _999_/VPB sky130_fd_sc_hd__decap_12
XFILLER_1_157 VSUBS VSUBS _999_/VPB _999_/VPB sky130_fd_sc_hd__decap_12
XTAP_TAPCELL_ROW_55_340 VSUBS _999_/VPB sky130_fd_sc_hd__tapvpwrvgnd_1
X_444_ _911_/Q VSUBS VSUBS _999_/VPB _999_/VPB _444_/Y sky130_fd_sc_hd__clkinv_1
X_513_ _944_/Q _980_/Q _540_/A VSUBS VSUBS _999_/VPB _999_/VPB _513_/Y sky130_fd_sc_hd__nand3_1
XFILLER_9_235 VSUBS VSUBS _999_/VPB _999_/VPB sky130_fd_sc_hd__decap_4
XFILLER_13_286 VSUBS VSUBS _999_/VPB _999_/VPB sky130_fd_sc_hd__fill_1
XFILLER_55_109 VSUBS VSUBS _999_/VPB _999_/VPB sky130_fd_sc_hd__decap_8
XTAP_TAPCELL_ROW_61_376 VSUBS _999_/VPB sky130_fd_sc_hd__tapvpwrvgnd_1
XFILLER_27_301 VSUBS VSUBS _999_/VPB _999_/VPB sky130_fd_sc_hd__fill_2
XTAP_TAPCELL_ROW_52_321 VSUBS _999_/VPB sky130_fd_sc_hd__tapvpwrvgnd_1
XFILLER_27_323 VSUBS VSUBS _999_/VPB _999_/VPB sky130_fd_sc_hd__decap_12
XFILLER_40_43 VSUBS VSUBS _999_/VPB _999_/VPB sky130_fd_sc_hd__decap_12
XFILLER_24_55 VSUBS VSUBS _999_/VPB _999_/VPB sky130_fd_sc_hd__decap_12
X_993_ VSUBS VSUBS _999_/VPB _999_/VPB _993_/HI STATUS_REG[9] sky130_fd_sc_hd__conb_1
XFILLER_40_87 VSUBS VSUBS _999_/VPB _999_/VPB sky130_fd_sc_hd__decap_3
XFILLER_49_85 VSUBS VSUBS _999_/VPB _999_/VPB sky130_fd_sc_hd__decap_12
XFILLER_37_109 VSUBS VSUBS _999_/VPB _999_/VPB sky130_fd_sc_hd__decap_8
XFILLER_1_48 VSUBS VSUBS _999_/VPB _999_/VPB sky130_fd_sc_hd__decap_12
XTAP_TAPCELL_ROW_10_68 VSUBS _999_/VPB sky130_fd_sc_hd__tapvpwrvgnd_1
XFILLER_10_24 VSUBS VSUBS _999_/VPB _999_/VPB sky130_fd_sc_hd__decap_6
XFILLER_10_79 VSUBS VSUBS _999_/VPB _999_/VPB sky130_fd_sc_hd__decap_8
XFILLER_59_256 VSUBS VSUBS _999_/VPB _999_/VPB sky130_fd_sc_hd__decap_12
XFILLER_59_223 VSUBS VSUBS _999_/VPB _999_/VPB sky130_fd_sc_hd__decap_8
XFILLER_19_109 VSUBS VSUBS _999_/VPB _999_/VPB sky130_fd_sc_hd__decap_8
XFILLER_27_153 VSUBS VSUBS _999_/VPB _999_/VPB sky130_fd_sc_hd__decap_12
XTAP_TAPCELL_ROW_6_47 VSUBS _999_/VPB sky130_fd_sc_hd__tapvpwrvgnd_1
XFILLER_51_97 VSUBS VSUBS _999_/VPB _999_/VPB sky130_fd_sc_hd__decap_12
X_976_ _981_/CLK _976_/D VSUBS VSUBS _999_/VPB _999_/VPB _976_/Q sky130_fd_sc_hd__dfxtp_1
XFILLER_33_145 VSUBS VSUBS _999_/VPB _999_/VPB sky130_fd_sc_hd__decap_12
XFILLER_18_175 VSUBS VSUBS _999_/VPB _999_/VPB sky130_fd_sc_hd__decap_12
XFILLER_44_0 VSUBS VSUBS _999_/VPB _999_/VPB sky130_fd_sc_hd__decap_12
XFILLER_56_259 VSUBS VSUBS _999_/VPB _999_/VPB sky130_fd_sc_hd__decap_8
XFILLER_2_91 VSUBS VSUBS _999_/VPB _999_/VPB sky130_fd_sc_hd__decap_12
XFILLER_12_329 VSUBS VSUBS _999_/VPB _999_/VPB sky130_fd_sc_hd__fill_1
XFILLER_21_12 VSUBS VSUBS _999_/VPB _999_/VPB sky130_fd_sc_hd__decap_12
X_761_ _758_/Y _759_/Y _760_/Y VSUBS VSUBS _999_/VPB _999_/VPB _934_/D sky130_fd_sc_hd__a21oi_1
X_830_ _962_/Q _873_/C _829_/Y VSUBS VSUBS _999_/VPB _999_/VPB _962_/D sky130_fd_sc_hd__a21oi_1
XFILLER_47_226 VSUBS VSUBS _999_/VPB _999_/VPB sky130_fd_sc_hd__decap_12
XFILLER_46_31 VSUBS VSUBS _999_/VPB _999_/VPB sky130_fd_sc_hd__decap_12
X_692_ _703_/A _692_/B VSUBS VSUBS _999_/VPB _999_/VPB _692_/Y sky130_fd_sc_hd__nand2_1
XFILLER_30_148 VSUBS VSUBS _999_/VPB _999_/VPB sky130_fd_sc_hd__fill_2
XFILLER_30_115 VSUBS VSUBS _999_/VPB _999_/VPB sky130_fd_sc_hd__decap_12
XFILLER_7_36 VSUBS VSUBS _999_/VPB _999_/VPB sky130_fd_sc_hd__decap_12
XFILLER_11_340 VSUBS VSUBS _999_/VPB _999_/VPB sky130_fd_sc_hd__decap_3
X_959_ _959_/CLK _959_/D VSUBS VSUBS _999_/VPB _999_/VPB _959_/Q sky130_fd_sc_hd__dfxtp_1
XFILLER_61_295 VSUBS VSUBS _999_/VPB _999_/VPB sky130_fd_sc_hd__decap_4
XTAP_TAPCELL_ROW_48_298 VSUBS _999_/VPB sky130_fd_sc_hd__tapvpwrvgnd_1
XTAP_TAPCELL_ROW_0_1 VSUBS _999_/VPB sky130_fd_sc_hd__tapvpwrvgnd_1
XTAP_TAPCELL_ROW_39_243 VSUBS _999_/VPB sky130_fd_sc_hd__tapvpwrvgnd_1
XFILLER_16_12 VSUBS VSUBS _999_/VPB _999_/VPB sky130_fd_sc_hd__decap_12
XFILLER_29_237 VSUBS VSUBS _999_/VPB _999_/VPB sky130_fd_sc_hd__decap_3
XFILLER_52_262 VSUBS VSUBS _999_/VPB _999_/VPB sky130_fd_sc_hd__decap_8
XFILLER_32_55 VSUBS VSUBS _999_/VPB _999_/VPB sky130_fd_sc_hd__decap_12
XFILLER_12_115 VSUBS VSUBS _999_/VPB _999_/VPB sky130_fd_sc_hd__decap_12
XFILLER_16_67 VSUBS VSUBS _999_/VPB _999_/VPB sky130_fd_sc_hd__decap_12
XTAP_TAPCELL_ROW_22_143 VSUBS _999_/VPB sky130_fd_sc_hd__tapvpwrvgnd_1
XTAP_TAPCELL_ROW_3_26 VSUBS _999_/VPB sky130_fd_sc_hd__tapvpwrvgnd_1
XFILLER_20_181 VSUBS VSUBS _999_/VPB _999_/VPB sky130_fd_sc_hd__fill_1
X_813_ _956_/Q _822_/B VSUBS VSUBS _999_/VPB _999_/VPB _815_/A sky130_fd_sc_hd__nor2_1
XFILLER_57_85 VSUBS VSUBS _999_/VPB _999_/VPB sky130_fd_sc_hd__decap_12
X_744_ _759_/S _742_/Y _743_/Y VSUBS VSUBS _999_/VPB _999_/VPB _931_/D sky130_fd_sc_hd__a21oi_1
XTAP_TAPCELL_ROW_45_279 VSUBS _999_/VPB sky130_fd_sc_hd__tapvpwrvgnd_1
X_675_ _951_/Q _662_/Y _459_/B VSUBS VSUBS _999_/VPB _999_/VPB _675_/Y sky130_fd_sc_hd__o21ai_0
XFILLER_11_181 VSUBS VSUBS _999_/VPB _999_/VPB sky130_fd_sc_hd__fill_2
XTAP_TAPCELL_ROW_36_224 VSUBS _999_/VPB sky130_fd_sc_hd__tapvpwrvgnd_1
XFILLER_26_207 VSUBS VSUBS _999_/VPB _999_/VPB sky130_fd_sc_hd__decap_3
X_460_ ESPI_BIT_TICK _961_/Q _960_/Q VSUBS VSUBS _999_/VPB _999_/VPB _873_/C sky130_fd_sc_hd__and3_1
XFILLER_4_199 VSUBS VSUBS _999_/VPB _999_/VPB sky130_fd_sc_hd__decap_8
X_727_ _929_/Q _946_/Q VSUBS VSUBS _999_/VPB _999_/VPB _753_/B sky130_fd_sc_hd__xor2_1
XFILLER_0_361 VSUBS VSUBS _999_/VPB _999_/VPB sky130_fd_sc_hd__decap_8
X_589_ _931_/Q _911_/Q VSUBS VSUBS _999_/VPB _999_/VPB _597_/A sky130_fd_sc_hd__xnor2_1
X_658_ _658_/A _658_/B VSUBS VSUBS _999_/VPB _999_/VPB _906_/D sky130_fd_sc_hd__nor2_1
XTAP_TAPCELL_ROW_33_205 VSUBS _999_/VPB sky130_fd_sc_hd__tapvpwrvgnd_1
XFILLER_16_251 VSUBS VSUBS _999_/VPB _999_/VPB sky130_fd_sc_hd__decap_12
XFILLER_54_346 VSUBS VSUBS _999_/VPB _999_/VPB sky130_fd_sc_hd__decap_12
XFILLER_13_24 VSUBS VSUBS _999_/VPB _999_/VPB sky130_fd_sc_hd__decap_12
XFILLER_45_313 VSUBS VSUBS _999_/VPB _999_/VPB sky130_fd_sc_hd__decap_12
XFILLER_38_87 VSUBS VSUBS _999_/VPB _999_/VPB sky130_fd_sc_hd__decap_3
XFILLER_38_43 VSUBS VSUBS _999_/VPB _999_/VPB sky130_fd_sc_hd__decap_12
XFILLER_1_169 VSUBS VSUBS _999_/VPB _999_/VPB sky130_fd_sc_hd__decap_8
XFILLER_60_327 VSUBS VSUBS _999_/VPB _999_/VPB sky130_fd_sc_hd__decap_3
X_443_ _912_/Q VSUBS VSUBS _999_/VPB _999_/VPB _443_/Y sky130_fd_sc_hd__clkinv_1
XTAP_TAPCELL_ROW_55_341 VSUBS _999_/VPB sky130_fd_sc_hd__tapvpwrvgnd_1
XFILLER_54_31 VSUBS VSUBS _999_/VPB _999_/VPB sky130_fd_sc_hd__decap_12
XFILLER_13_221 VSUBS VSUBS _999_/VPB _999_/VPB sky130_fd_sc_hd__decap_8
X_512_ _982_/Q _512_/B VSUBS VSUBS _999_/VPB _999_/VPB _512_/Y sky130_fd_sc_hd__nor2_1
XFILLER_48_173 VSUBS VSUBS _999_/VPB _999_/VPB sky130_fd_sc_hd__decap_8
XFILLER_48_151 VSUBS VSUBS _999_/VPB _999_/VPB sky130_fd_sc_hd__decap_12
XFILLER_36_368 VSUBS VSUBS _999_/VPB _999_/VPB sky130_fd_sc_hd__fill_1
XTAP_TAPCELL_ROW_61_377 VSUBS _999_/VPB sky130_fd_sc_hd__tapvpwrvgnd_1
XFILLER_27_335 VSUBS VSUBS _999_/VPB _999_/VPB sky130_fd_sc_hd__decap_8
XTAP_TAPCELL_ROW_52_322 VSUBS _999_/VPB sky130_fd_sc_hd__tapvpwrvgnd_1
XFILLER_24_12 VSUBS VSUBS _999_/VPB _999_/VPB sky130_fd_sc_hd__decap_12
XFILLER_24_67 VSUBS VSUBS _999_/VPB _999_/VPB sky130_fd_sc_hd__decap_12
XFILLER_40_55 VSUBS VSUBS _999_/VPB _999_/VPB sky130_fd_sc_hd__decap_12
XFILLER_49_97 VSUBS VSUBS _999_/VPB _999_/VPB sky130_fd_sc_hd__decap_12
X_992_ VSUBS VSUBS _999_/VPB _999_/VPB _992_/HI STATUS_REG[8] sky130_fd_sc_hd__conb_1
XFILLER_45_154 VSUBS VSUBS _999_/VPB _999_/VPB sky130_fd_sc_hd__decap_12
XFILLER_45_121 VSUBS VSUBS _999_/VPB _999_/VPB sky130_fd_sc_hd__decap_12
XFILLER_18_324 VSUBS VSUBS _999_/VPB _999_/VPB sky130_fd_sc_hd__decap_3
XFILLER_18_368 VSUBS VSUBS _999_/VPB _999_/VPB sky130_fd_sc_hd__fill_1
XFILLER_33_338 VSUBS VSUBS _999_/VPB _999_/VPB sky130_fd_sc_hd__decap_6
XTAP_TAPCELL_ROW_10_69 VSUBS _999_/VPB sky130_fd_sc_hd__tapvpwrvgnd_1
XFILLER_19_12 VSUBS VSUBS _999_/VPB _999_/VPB sky130_fd_sc_hd__decap_12
XFILLER_59_268 VSUBS VSUBS _999_/VPB _999_/VPB sky130_fd_sc_hd__decap_12
XFILLER_27_121 VSUBS VSUBS _999_/VPB _999_/VPB sky130_fd_sc_hd__decap_12
XFILLER_27_165 VSUBS VSUBS _999_/VPB _999_/VPB sky130_fd_sc_hd__decap_12
XFILLER_4_0 VSUBS VSUBS _999_/VPB _999_/VPB sky130_fd_sc_hd__decap_12
X_975_ _983_/CLK _975_/D VSUBS VSUBS _999_/VPB _999_/VPB _975_/Q sky130_fd_sc_hd__dfxtp_1
XFILLER_33_157 VSUBS VSUBS _999_/VPB _999_/VPB sky130_fd_sc_hd__decap_12
XFILLER_18_187 VSUBS VSUBS _999_/VPB _999_/VPB sky130_fd_sc_hd__decap_8
XFILLER_37_0 VSUBS VSUBS _999_/VPB _999_/VPB sky130_fd_sc_hd__decap_12
XFILLER_21_24 VSUBS VSUBS _999_/VPB _999_/VPB sky130_fd_sc_hd__decap_12
X_760_ _747_/Y _758_/Y _873_/B VSUBS VSUBS _999_/VPB _999_/VPB _760_/Y sky130_fd_sc_hd__o21ai_0
XFILLER_55_293 VSUBS VSUBS _999_/VPB _999_/VPB sky130_fd_sc_hd__decap_6
XFILLER_47_238 VSUBS VSUBS _999_/VPB _999_/VPB sky130_fd_sc_hd__fill_2
XFILLER_46_87 VSUBS VSUBS _999_/VPB _999_/VPB sky130_fd_sc_hd__decap_3
XFILLER_46_43 VSUBS VSUBS _999_/VPB _999_/VPB sky130_fd_sc_hd__decap_12
X_691_ _438_/Y _690_/Y _978_/Q VSUBS VSUBS _999_/VPB _999_/VPB _692_/B sky130_fd_sc_hd__o21ai_0
XTAP_TAPCELL_ROW_17_108 VSUBS _999_/VPB sky130_fd_sc_hd__tapvpwrvgnd_1
XFILLER_30_127 VSUBS VSUBS _999_/VPB _999_/VPB sky130_fd_sc_hd__decap_8
XFILLER_7_301 VSUBS VSUBS _999_/VPB _999_/VPB sky130_fd_sc_hd__decap_12
XFILLER_7_48 VSUBS VSUBS _999_/VPB _999_/VPB sky130_fd_sc_hd__decap_12
XFILLER_15_179 VSUBS VSUBS _999_/VPB _999_/VPB sky130_fd_sc_hd__fill_1
X_958_ _959_/CLK _958_/D VSUBS VSUBS _999_/VPB _999_/VPB _958_/Q sky130_fd_sc_hd__dfxtp_1
X_889_ _970_/CLK _889_/D VSUBS VSUBS _999_/VPB _999_/VPB _889_/Q sky130_fd_sc_hd__dfxtp_1
XFILLER_61_241 VSUBS VSUBS _999_/VPB _999_/VPB sky130_fd_sc_hd__decap_12
XTAP_TAPCELL_ROW_48_299 VSUBS _999_/VPB sky130_fd_sc_hd__tapvpwrvgnd_1
XFILLER_46_271 VSUBS VSUBS _999_/VPB _999_/VPB sky130_fd_sc_hd__decap_12
XTAP_TAPCELL_ROW_0_2 VSUBS _999_/VPB sky130_fd_sc_hd__tapvpwrvgnd_1
XFILLER_52_252 VSUBS VSUBS _999_/VPB _999_/VPB sky130_fd_sc_hd__fill_1
XFILLER_44_219 VSUBS VSUBS _999_/VPB _999_/VPB sky130_fd_sc_hd__fill_2
XTAP_TAPCELL_ROW_39_244 VSUBS _999_/VPB sky130_fd_sc_hd__tapvpwrvgnd_1
XFILLER_16_24 VSUBS VSUBS _999_/VPB _999_/VPB sky130_fd_sc_hd__decap_6
XFILLER_32_67 VSUBS VSUBS _999_/VPB _999_/VPB sky130_fd_sc_hd__decap_12
XFILLER_32_12 VSUBS VSUBS _999_/VPB _999_/VPB sky130_fd_sc_hd__decap_12
XTAP_TAPCELL_ROW_3_27 VSUBS _999_/VPB sky130_fd_sc_hd__tapvpwrvgnd_1
XFILLER_12_127 VSUBS VSUBS _999_/VPB _999_/VPB sky130_fd_sc_hd__decap_12
XFILLER_16_79 VSUBS VSUBS _999_/VPB _999_/VPB sky130_fd_sc_hd__decap_8
X_812_ _812_/A _812_/B VSUBS VSUBS _999_/VPB _999_/VPB _955_/D sky130_fd_sc_hd__nor2_1
X_674_ _442_/Y _662_/Y _673_/Y VSUBS VSUBS _999_/VPB _999_/VPB _913_/D sky130_fd_sc_hd__a21oi_1
XFILLER_57_97 VSUBS VSUBS _999_/VPB _999_/VPB sky130_fd_sc_hd__decap_12
X_743_ _931_/Q _759_/S _873_/B VSUBS VSUBS _999_/VPB _999_/VPB _743_/Y sky130_fd_sc_hd__o21ai_0
XFILLER_43_241 VSUBS VSUBS _999_/VPB _999_/VPB sky130_fd_sc_hd__decap_12
XFILLER_28_271 VSUBS VSUBS _999_/VPB _999_/VPB sky130_fd_sc_hd__decap_12
XFILLER_7_197 VSUBS VSUBS _999_/VPB _999_/VPB sky130_fd_sc_hd__decap_12
XTAP_TAPCELL_ROW_36_225 VSUBS _999_/VPB sky130_fd_sc_hd__tapvpwrvgnd_1
XFILLER_34_230 VSUBS VSUBS _999_/VPB _999_/VPB sky130_fd_sc_hd__decap_12
XFILLER_26_219 VSUBS VSUBS _999_/VPB _999_/VPB sky130_fd_sc_hd__decap_3
XFILLER_34_285 VSUBS VSUBS _999_/VPB _999_/VPB sky130_fd_sc_hd__decap_12
XFILLER_8_91 VSUBS VSUBS _999_/VPB _999_/VPB sky130_fd_sc_hd__decap_12
XFILLER_17_219 VSUBS VSUBS _999_/VPB _999_/VPB sky130_fd_sc_hd__decap_8
XFILLER_27_12 VSUBS VSUBS _999_/VPB _999_/VPB sky130_fd_sc_hd__decap_12
XFILLER_40_211 VSUBS VSUBS _999_/VPB _999_/VPB sky130_fd_sc_hd__decap_8
XFILLER_40_200 VSUBS VSUBS _999_/VPB _999_/VPB sky130_fd_sc_hd__decap_8
XFILLER_25_252 VSUBS VSUBS _999_/VPB _999_/VPB sky130_fd_sc_hd__decap_12
XFILLER_40_277 VSUBS VSUBS _999_/VPB _999_/VPB sky130_fd_sc_hd__decap_12
XFILLER_40_266 VSUBS VSUBS _999_/VPB _999_/VPB sky130_fd_sc_hd__fill_1
X_726_ _930_/Q _947_/Q VSUBS VSUBS _999_/VPB _999_/VPB _738_/A sky130_fd_sc_hd__xor2_1
X_657_ LAST_CMD[6] _659_/B _459_/B VSUBS VSUBS _999_/VPB _999_/VPB _658_/B sky130_fd_sc_hd__o21ai_0
XTAP_TAPCELL_ROW_33_206 VSUBS _999_/VPB sky130_fd_sc_hd__tapvpwrvgnd_1
XFILLER_31_288 VSUBS VSUBS _999_/VPB _999_/VPB sky130_fd_sc_hd__decap_12
X_588_ CRC_ERROR _526_/C _982_/Q VSUBS VSUBS _999_/VPB _999_/VPB _601_/A sky130_fd_sc_hd__a21oi_1
XFILLER_16_263 VSUBS VSUBS _999_/VPB _999_/VPB sky130_fd_sc_hd__decap_6
XFILLER_54_303 VSUBS VSUBS _999_/VPB _999_/VPB sky130_fd_sc_hd__decap_12
XFILLER_54_358 VSUBS VSUBS _999_/VPB _999_/VPB sky130_fd_sc_hd__decap_8
XFILLER_22_211 VSUBS VSUBS _999_/VPB _999_/VPB sky130_fd_sc_hd__decap_12
XFILLER_13_36 VSUBS VSUBS _999_/VPB _999_/VPB sky130_fd_sc_hd__decap_12
XFILLER_57_185 VSUBS VSUBS _999_/VPB _999_/VPB sky130_fd_sc_hd__decap_8
XFILLER_45_325 VSUBS VSUBS _999_/VPB _999_/VPB sky130_fd_sc_hd__decap_8
XFILLER_38_55 VSUBS VSUBS _999_/VPB _999_/VPB sky130_fd_sc_hd__decap_12
X_511_ _892_/Q _891_/Q _977_/Q VSUBS VSUBS _999_/VPB _999_/VPB _512_/B sky130_fd_sc_hd__o21a_1
X_442_ _913_/Q VSUBS VSUBS _999_/VPB _999_/VPB _442_/Y sky130_fd_sc_hd__clkinv_1
XFILLER_54_87 VSUBS VSUBS _999_/VPB _999_/VPB sky130_fd_sc_hd__decap_3
XFILLER_54_43 VSUBS VSUBS _999_/VPB _999_/VPB sky130_fd_sc_hd__decap_12
XFILLER_9_226 VSUBS VSUBS _999_/VPB _999_/VPB sky130_fd_sc_hd__decap_3
XFILLER_9_248 VSUBS VSUBS _999_/VPB _999_/VPB sky130_fd_sc_hd__decap_8
XFILLER_13_299 VSUBS VSUBS _999_/VPB _999_/VPB sky130_fd_sc_hd__fill_1
XFILLER_0_181 VSUBS VSUBS _999_/VPB _999_/VPB sky130_fd_sc_hd__decap_12
X_709_ _723_/A _709_/B VSUBS VSUBS _999_/VPB _999_/VPB _920_/D sky130_fd_sc_hd__nor2_1
XFILLER_48_163 VSUBS VSUBS _999_/VPB _999_/VPB sky130_fd_sc_hd__decap_3
XTAP_TAPCELL_ROW_61_378 VSUBS _999_/VPB sky130_fd_sc_hd__tapvpwrvgnd_1
XTAP_TAPCELL_ROW_52_323 VSUBS _999_/VPB sky130_fd_sc_hd__tapvpwrvgnd_1
XFILLER_42_306 VSUBS VSUBS _999_/VPB _999_/VPB sky130_fd_sc_hd__fill_1
XFILLER_24_24 VSUBS VSUBS _999_/VPB _999_/VPB sky130_fd_sc_hd__decap_6
XFILLER_24_79 VSUBS VSUBS _999_/VPB _999_/VPB sky130_fd_sc_hd__decap_8
XFILLER_40_67 VSUBS VSUBS _999_/VPB _999_/VPB sky130_fd_sc_hd__decap_12
XFILLER_40_12 VSUBS VSUBS _999_/VPB _999_/VPB sky130_fd_sc_hd__decap_12
XTAP_TAPCELL_ROW_14_90 VSUBS _999_/VPB sky130_fd_sc_hd__tapvpwrvgnd_1
X_991_ VSUBS VSUBS _999_/VPB _999_/VPB _991_/HI STATUS_REG[7] sky130_fd_sc_hd__conb_1
XFILLER_60_103 VSUBS VSUBS _999_/VPB _999_/VPB sky130_fd_sc_hd__decap_12
XFILLER_45_177 VSUBS VSUBS _999_/VPB _999_/VPB sky130_fd_sc_hd__decap_3
XFILLER_45_166 VSUBS VSUBS _999_/VPB _999_/VPB sky130_fd_sc_hd__decap_4
XFILLER_45_144 VSUBS VSUBS _999_/VPB _999_/VPB sky130_fd_sc_hd__fill_2
XFILLER_45_133 VSUBS VSUBS _999_/VPB _999_/VPB sky130_fd_sc_hd__decap_3
XFILLER_60_147 VSUBS VSUBS _999_/VPB _999_/VPB sky130_fd_sc_hd__decap_3
XFILLER_41_361 VSUBS VSUBS _999_/VPB _999_/VPB sky130_fd_sc_hd__decap_8
XFILLER_36_188 VSUBS VSUBS _999_/VPB _999_/VPB sky130_fd_sc_hd__fill_1
XFILLER_36_155 VSUBS VSUBS _999_/VPB _999_/VPB sky130_fd_sc_hd__decap_8
XFILLER_19_24 VSUBS VSUBS _999_/VPB _999_/VPB sky130_fd_sc_hd__decap_12
XFILLER_42_103 VSUBS VSUBS _999_/VPB _999_/VPB sky130_fd_sc_hd__decap_12
XFILLER_35_12 VSUBS VSUBS _999_/VPB _999_/VPB sky130_fd_sc_hd__decap_12
XFILLER_15_339 VSUBS VSUBS _999_/VPB _999_/VPB sky130_fd_sc_hd__fill_1
XFILLER_27_133 VSUBS VSUBS _999_/VPB _999_/VPB sky130_fd_sc_hd__decap_8
XFILLER_27_177 VSUBS VSUBS _999_/VPB _999_/VPB sky130_fd_sc_hd__decap_3
XFILLER_23_361 VSUBS VSUBS _999_/VPB _999_/VPB sky130_fd_sc_hd__decap_8
XFILLER_2_232 VSUBS VSUBS _999_/VPB _999_/VPB sky130_fd_sc_hd__fill_1
X_974_ _983_/CLK _974_/D VSUBS VSUBS _999_/VPB _999_/VPB _974_/Q sky130_fd_sc_hd__dfxtp_1
XFILLER_2_287 VSUBS VSUBS _999_/VPB _999_/VPB sky130_fd_sc_hd__decap_12
XFILLER_33_169 VSUBS VSUBS _999_/VPB _999_/VPB sky130_fd_sc_hd__decap_8
XFILLER_18_144 VSUBS VSUBS _999_/VPB _999_/VPB sky130_fd_sc_hd__decap_6
XFILLER_18_199 VSUBS VSUBS _999_/VPB _999_/VPB sky130_fd_sc_hd__decap_3
XFILLER_24_103 VSUBS VSUBS _999_/VPB _999_/VPB sky130_fd_sc_hd__decap_12
XFILLER_20_331 VSUBS VSUBS _999_/VPB _999_/VPB sky130_fd_sc_hd__fill_1
XFILLER_24_147 VSUBS VSUBS _999_/VPB _999_/VPB sky130_fd_sc_hd__decap_3
XFILLER_21_36 VSUBS VSUBS _999_/VPB _999_/VPB sky130_fd_sc_hd__decap_12
X_690_ _925_/Q _690_/B _701_/B VSUBS VSUBS _999_/VPB _999_/VPB _690_/Y sky130_fd_sc_hd__nand3_1
XFILLER_46_55 VSUBS VSUBS _999_/VPB _999_/VPB sky130_fd_sc_hd__decap_12
XFILLER_15_147 VSUBS VSUBS _999_/VPB _999_/VPB sky130_fd_sc_hd__decap_12
XTAP_TAPCELL_ROW_17_109 VSUBS _999_/VPB sky130_fd_sc_hd__tapvpwrvgnd_1
XFILLER_7_313 VSUBS VSUBS _999_/VPB _999_/VPB sky130_fd_sc_hd__decap_12
XFILLER_7_357 VSUBS VSUBS _999_/VPB _999_/VPB sky130_fd_sc_hd__decap_3
X_957_ _959_/CLK _957_/D VSUBS VSUBS _999_/VPB _999_/VPB _957_/Q sky130_fd_sc_hd__dfxtp_1
XFILLER_46_283 VSUBS VSUBS _999_/VPB _999_/VPB sky130_fd_sc_hd__decap_12
X_888_ _969_/CLK _888_/D VSUBS VSUBS _999_/VPB _999_/VPB _888_/Q sky130_fd_sc_hd__dfxtp_1
XFILLER_61_253 VSUBS VSUBS _999_/VPB _999_/VPB sky130_fd_sc_hd__decap_12
XFILLER_21_117 VSUBS VSUBS _999_/VPB _999_/VPB sky130_fd_sc_hd__decap_3
XTAP_TAPCELL_ROW_0_3 VSUBS _999_/VPB sky130_fd_sc_hd__tapvpwrvgnd_1
Xspare_mux2_0 spare_mux2_0/A0 spare_mux2_0/A1 spare_mux2_0/S VSUBS VSUBS _999_/VPB
+ _999_/VPB spare_mux2_0/X sky130_fd_sc_hd__mux2_1
XFILLER_44_209 VSUBS VSUBS _999_/VPB _999_/VPB sky130_fd_sc_hd__fill_1
XTAP_TAPCELL_ROW_39_245 VSUBS _999_/VPB sky130_fd_sc_hd__tapvpwrvgnd_1
XFILLER_32_79 VSUBS VSUBS _999_/VPB _999_/VPB sky130_fd_sc_hd__decap_8
XFILLER_32_24 VSUBS VSUBS _999_/VPB _999_/VPB sky130_fd_sc_hd__decap_6
XTAP_TAPCELL_ROW_3_28 VSUBS _999_/VPB sky130_fd_sc_hd__tapvpwrvgnd_1
XFILLER_12_139 VSUBS VSUBS _999_/VPB _999_/VPB sky130_fd_sc_hd__decap_8
X_811_ _954_/Q _803_/Y _459_/B VSUBS VSUBS _999_/VPB _999_/VPB _812_/B sky130_fd_sc_hd__o21ai_0
X_673_ _950_/Q _662_/Y _459_/B VSUBS VSUBS _999_/VPB _999_/VPB _673_/Y sky130_fd_sc_hd__o21ai_0
X_742_ _742_/A _748_/A VSUBS VSUBS _999_/VPB _999_/VPB _742_/Y sky130_fd_sc_hd__xnor2_1
XFILLER_28_283 VSUBS VSUBS _999_/VPB _999_/VPB sky130_fd_sc_hd__decap_12
XFILLER_43_253 VSUBS VSUBS _999_/VPB _999_/VPB sky130_fd_sc_hd__decap_6
XFILLER_7_121 VSUBS VSUBS _999_/VPB _999_/VPB sky130_fd_sc_hd__decap_12
XTAP_TAPCELL_ROW_36_226 VSUBS _999_/VPB sky130_fd_sc_hd__tapvpwrvgnd_1
XFILLER_34_242 VSUBS VSUBS _999_/VPB _999_/VPB sky130_fd_sc_hd__fill_2
XTAP_TAPCELL_ROW_44_270 VSUBS _999_/VPB sky130_fd_sc_hd__tapvpwrvgnd_1
XFILLER_34_297 VSUBS VSUBS _999_/VPB _999_/VPB sky130_fd_sc_hd__decap_12
XFILLER_57_301 VSUBS VSUBS _999_/VPB _999_/VPB sky130_fd_sc_hd__decap_8
XFILLER_27_24 VSUBS VSUBS _999_/VPB _999_/VPB sky130_fd_sc_hd__decap_12
XFILLER_43_12 VSUBS VSUBS _999_/VPB _999_/VPB sky130_fd_sc_hd__decap_6
XFILLER_25_264 VSUBS VSUBS _999_/VPB _999_/VPB sky130_fd_sc_hd__decap_12
XFILLER_40_289 VSUBS VSUBS _999_/VPB _999_/VPB sky130_fd_sc_hd__decap_12
XFILLER_48_345 VSUBS VSUBS _999_/VPB _999_/VPB sky130_fd_sc_hd__decap_12
X_725_ _928_/Q _945_/Q VSUBS VSUBS _999_/VPB _999_/VPB _753_/A sky130_fd_sc_hd__xnor2_1
X_656_ _656_/A _656_/B VSUBS VSUBS _999_/VPB _999_/VPB _905_/D sky130_fd_sc_hd__nor2_1
XTAP_TAPCELL_ROW_33_207 VSUBS _999_/VPB sky130_fd_sc_hd__tapvpwrvgnd_1
XFILLER_16_231 VSUBS VSUBS _999_/VPB _999_/VPB sky130_fd_sc_hd__decap_8
X_587_ ESPI_CS_N EVENT_PENDING _587_/C VSUBS VSUBS _999_/VPB _999_/VPB _889_/D sky130_fd_sc_hd__and3_1
XFILLER_16_286 VSUBS VSUBS _999_/VPB _999_/VPB sky130_fd_sc_hd__decap_12
XFILLER_54_315 VSUBS VSUBS _999_/VPB _999_/VPB sky130_fd_sc_hd__decap_12
XFILLER_39_345 VSUBS VSUBS _999_/VPB _999_/VPB sky130_fd_sc_hd__decap_3
XFILLER_39_301 VSUBS VSUBS _999_/VPB _999_/VPB sky130_fd_sc_hd__decap_12
XFILLER_12_0 VSUBS VSUBS _999_/VPB _999_/VPB sky130_fd_sc_hd__decap_12
XFILLER_22_223 VSUBS VSUBS _999_/VPB _999_/VPB sky130_fd_sc_hd__decap_12
XFILLER_22_267 VSUBS VSUBS _999_/VPB _999_/VPB sky130_fd_sc_hd__decap_3
XFILLER_13_48 VSUBS VSUBS _999_/VPB _999_/VPB sky130_fd_sc_hd__decap_12
XFILLER_22_289 VSUBS VSUBS _999_/VPB _999_/VPB sky130_fd_sc_hd__decap_12
XFILLER_49_109 VSUBS VSUBS _999_/VPB _999_/VPB sky130_fd_sc_hd__decap_8
XFILLER_38_12 VSUBS VSUBS _999_/VPB _999_/VPB sky130_fd_sc_hd__decap_12
XFILLER_60_307 VSUBS VSUBS _999_/VPB _999_/VPB sky130_fd_sc_hd__decap_12
XFILLER_54_55 VSUBS VSUBS _999_/VPB _999_/VPB sky130_fd_sc_hd__decap_12
XFILLER_45_359 VSUBS VSUBS _999_/VPB _999_/VPB sky130_fd_sc_hd__fill_1
X_441_ _914_/Q VSUBS VSUBS _999_/VPB _999_/VPB _441_/Y sky130_fd_sc_hd__clkinv_1
XFILLER_38_67 VSUBS VSUBS _999_/VPB _999_/VPB sky130_fd_sc_hd__decap_12
X_510_ _723_/A _540_/A _509_/Y _504_/Y VSUBS VSUBS _999_/VPB _999_/VPB _978_/D sky130_fd_sc_hd__o31ai_1
XFILLER_13_234 VSUBS VSUBS _999_/VPB _999_/VPB sky130_fd_sc_hd__decap_6
XFILLER_0_193 VSUBS VSUBS _999_/VPB _999_/VPB sky130_fd_sc_hd__decap_12
XFILLER_51_307 VSUBS VSUBS _999_/VPB _999_/VPB sky130_fd_sc_hd__decap_12
X_708_ _920_/Q _945_/Q _722_/S VSUBS VSUBS _999_/VPB _999_/VPB _709_/B sky130_fd_sc_hd__mux2i_1
X_639_ _899_/Q _873_/B _639_/C VSUBS VSUBS _999_/VPB _999_/VPB _899_/D sky130_fd_sc_hd__and3_1
XTAP_TAPCELL_ROW_61_379 VSUBS _999_/VPB sky130_fd_sc_hd__tapvpwrvgnd_1
XFILLER_8_271 VSUBS VSUBS _999_/VPB _999_/VPB sky130_fd_sc_hd__decap_12
XFILLER_42_329 VSUBS VSUBS _999_/VPB _999_/VPB sky130_fd_sc_hd__fill_1
XFILLER_10_215 VSUBS VSUBS _999_/VPB _999_/VPB sky130_fd_sc_hd__fill_1
XFILLER_40_79 VSUBS VSUBS _999_/VPB _999_/VPB sky130_fd_sc_hd__decap_8
XFILLER_40_24 VSUBS VSUBS _999_/VPB _999_/VPB sky130_fd_sc_hd__decap_6
X_990_ VSUBS VSUBS _999_/VPB _999_/VPB _990_/HI STATUS_REG[6] sky130_fd_sc_hd__conb_1
XTAP_TAPCELL_ROW_14_91 VSUBS _999_/VPB sky130_fd_sc_hd__tapvpwrvgnd_1
XFILLER_60_115 VSUBS VSUBS _999_/VPB _999_/VPB sky130_fd_sc_hd__decap_12
XFILLER_14_91 VSUBS VSUBS _999_/VPB _999_/VPB sky130_fd_sc_hd__decap_12
XFILLER_5_274 VSUBS VSUBS _999_/VPB _999_/VPB sky130_fd_sc_hd__decap_12
XFILLER_5_241 VSUBS VSUBS _999_/VPB _999_/VPB sky130_fd_sc_hd__decap_12
XFILLER_59_237 VSUBS VSUBS _999_/VPB _999_/VPB sky130_fd_sc_hd__decap_3
XFILLER_19_36 VSUBS VSUBS _999_/VPB _999_/VPB sky130_fd_sc_hd__decap_12
XFILLER_42_115 VSUBS VSUBS _999_/VPB _999_/VPB sky130_fd_sc_hd__decap_12
XFILLER_35_24 VSUBS VSUBS _999_/VPB _999_/VPB sky130_fd_sc_hd__decap_12
XFILLER_15_307 VSUBS VSUBS _999_/VPB _999_/VPB sky130_fd_sc_hd__decap_12
XFILLER_51_12 VSUBS VSUBS _999_/VPB _999_/VPB sky130_fd_sc_hd__decap_12
XFILLER_50_170 VSUBS VSUBS _999_/VPB _999_/VPB sky130_fd_sc_hd__decap_6
Xclkbuf_3_3__f_clk clkbuf_0_clk/X VSUBS VSUBS _999_/VPB _999_/VPB _970_/CLK sky130_fd_sc_hd__clkbuf_16
XFILLER_2_299 VSUBS VSUBS _999_/VPB _999_/VPB sky130_fd_sc_hd__decap_8
XFILLER_2_211 VSUBS VSUBS _999_/VPB _999_/VPB sky130_fd_sc_hd__decap_12
X_973_ _983_/CLK _973_/D VSUBS VSUBS _999_/VPB _999_/VPB _973_/Q sky130_fd_sc_hd__dfxtp_1
XFILLER_41_181 VSUBS VSUBS _999_/VPB _999_/VPB sky130_fd_sc_hd__fill_2
XFILLER_56_207 VSUBS VSUBS _999_/VPB _999_/VPB sky130_fd_sc_hd__decap_3
XFILLER_24_115 VSUBS VSUBS _999_/VPB _999_/VPB sky130_fd_sc_hd__decap_12
XFILLER_32_181 VSUBS VSUBS _999_/VPB _999_/VPB sky130_fd_sc_hd__fill_1
XFILLER_20_354 VSUBS VSUBS _999_/VPB _999_/VPB sky130_fd_sc_hd__decap_12
XFILLER_21_48 VSUBS VSUBS _999_/VPB _999_/VPB sky130_fd_sc_hd__decap_12
XFILLER_46_67 VSUBS VSUBS _999_/VPB _999_/VPB sky130_fd_sc_hd__decap_12
XFILLER_46_12 VSUBS VSUBS _999_/VPB _999_/VPB sky130_fd_sc_hd__decap_12
XFILLER_11_321 VSUBS VSUBS _999_/VPB _999_/VPB sky130_fd_sc_hd__decap_3
XFILLER_15_159 VSUBS VSUBS _999_/VPB _999_/VPB sky130_fd_sc_hd__decap_12
XFILLER_23_181 VSUBS VSUBS _999_/VPB _999_/VPB sky130_fd_sc_hd__decap_8
XFILLER_7_325 VSUBS VSUBS _999_/VPB _999_/VPB sky130_fd_sc_hd__decap_12
X_956_ _959_/CLK _956_/D VSUBS VSUBS _999_/VPB _999_/VPB _956_/Q sky130_fd_sc_hd__dfxtp_1
XFILLER_38_207 VSUBS VSUBS _999_/VPB _999_/VPB sky130_fd_sc_hd__decap_3
X_887_ _969_/CLK _887_/D VSUBS VSUBS _999_/VPB _999_/VPB _887_/Q sky130_fd_sc_hd__dfxtp_1
XFILLER_61_265 VSUBS VSUBS _999_/VPB _999_/VPB sky130_fd_sc_hd__decap_4
XTAP_TAPCELL_ROW_0_4 VSUBS _999_/VPB sky130_fd_sc_hd__tapvpwrvgnd_1
XFILLER_14_181 VSUBS VSUBS _999_/VPB _999_/VPB sky130_fd_sc_hd__fill_1
XFILLER_42_0 VSUBS VSUBS _999_/VPB _999_/VPB sky130_fd_sc_hd__decap_12
Xspare_mux2_1 spare_mux2_1/A0 spare_mux2_1/A1 spare_mux2_1/S VSUBS VSUBS _999_/VPB
+ _999_/VPB spare_mux2_1/X sky130_fd_sc_hd__mux2_1
XTAP_TAPCELL_ROW_47_290 VSUBS _999_/VPB sky130_fd_sc_hd__tapvpwrvgnd_1
XTAP_TAPCELL_ROW_30_190 VSUBS _999_/VPB sky130_fd_sc_hd__tapvpwrvgnd_1
XTAP_TAPCELL_ROW_3_29 VSUBS _999_/VPB sky130_fd_sc_hd__tapvpwrvgnd_1
X_810_ _955_/Q _822_/B VSUBS VSUBS _999_/VPB _999_/VPB _812_/A sky130_fd_sc_hd__nor2_1
X_672_ _443_/Y _662_/Y _671_/Y VSUBS VSUBS _999_/VPB _999_/VPB _912_/D sky130_fd_sc_hd__a21oi_1
X_741_ _933_/Q _950_/Q VSUBS VSUBS _999_/VPB _999_/VPB _748_/A sky130_fd_sc_hd__xor2_1
XFILLER_7_133 VSUBS VSUBS _999_/VPB _999_/VPB sky130_fd_sc_hd__decap_12
XFILLER_3_361 VSUBS VSUBS _999_/VPB _999_/VPB sky130_fd_sc_hd__decap_8
XFILLER_22_91 VSUBS VSUBS _999_/VPB _999_/VPB sky130_fd_sc_hd__decap_12
X_939_ _983_/CLK _939_/D VSUBS VSUBS _999_/VPB _999_/VPB _939_/Q sky130_fd_sc_hd__dfxtp_1
XTAP_TAPCELL_ROW_44_271 VSUBS _999_/VPB sky130_fd_sc_hd__tapvpwrvgnd_1
XTAP_TAPCELL_ROW_36_227 VSUBS _999_/VPB sky130_fd_sc_hd__tapvpwrvgnd_1
XFILLER_25_221 VSUBS VSUBS _999_/VPB _999_/VPB sky130_fd_sc_hd__fill_2
XFILLER_27_36 VSUBS VSUBS _999_/VPB _999_/VPB sky130_fd_sc_hd__decap_12
XFILLER_4_147 VSUBS VSUBS _999_/VPB _999_/VPB sky130_fd_sc_hd__decap_3
XFILLER_4_103 VSUBS VSUBS _999_/VPB _999_/VPB sky130_fd_sc_hd__decap_12
XFILLER_48_357 VSUBS VSUBS _999_/VPB _999_/VPB sky130_fd_sc_hd__decap_12
X_724_ _978_/Q _976_/Q _980_/Q _944_/Q VSUBS VSUBS _999_/VPB _999_/VPB _759_/S sky130_fd_sc_hd__o31a_1
Xspare_nand2_0 spare_nand2_0/A spare_nand2_0/B VSUBS VSUBS _999_/VPB _999_/VPB spare_nand2_0/Y
+ sky130_fd_sc_hd__nand2_1
XFILLER_0_331 VSUBS VSUBS _999_/VPB _999_/VPB sky130_fd_sc_hd__decap_12
X_655_ _950_/Q _526_/C _459_/B VSUBS VSUBS _999_/VPB _999_/VPB _656_/B sky130_fd_sc_hd__o21ai_0
XTAP_TAPCELL_ROW_33_208 VSUBS _999_/VPB sky130_fd_sc_hd__tapvpwrvgnd_1
X_586_ _723_/A _586_/B VSUBS VSUBS _999_/VPB _999_/VPB _888_/D sky130_fd_sc_hd__nor2_1
XFILLER_16_298 VSUBS VSUBS _999_/VPB _999_/VPB sky130_fd_sc_hd__decap_12
XTAP_TAPCELL_ROW_41_252 VSUBS _999_/VPB sky130_fd_sc_hd__tapvpwrvgnd_1
XFILLER_54_327 VSUBS VSUBS _999_/VPB _999_/VPB sky130_fd_sc_hd__decap_3
XFILLER_39_313 VSUBS VSUBS _999_/VPB _999_/VPB sky130_fd_sc_hd__decap_12
XFILLER_22_202 VSUBS VSUBS _999_/VPB _999_/VPB sky130_fd_sc_hd__fill_1
XFILLER_22_235 VSUBS VSUBS _999_/VPB _999_/VPB sky130_fd_sc_hd__decap_12
XFILLER_57_121 VSUBS VSUBS _999_/VPB _999_/VPB sky130_fd_sc_hd__decap_12
XFILLER_38_79 VSUBS VSUBS _999_/VPB _999_/VPB sky130_fd_sc_hd__decap_8
XFILLER_38_24 VSUBS VSUBS _999_/VPB _999_/VPB sky130_fd_sc_hd__decap_6
XFILLER_1_117 VSUBS VSUBS _999_/VPB _999_/VPB sky130_fd_sc_hd__decap_3
XFILLER_60_319 VSUBS VSUBS _999_/VPB _999_/VPB sky130_fd_sc_hd__decap_8
XFILLER_54_67 VSUBS VSUBS _999_/VPB _999_/VPB sky130_fd_sc_hd__decap_12
XFILLER_54_12 VSUBS VSUBS _999_/VPB _999_/VPB sky130_fd_sc_hd__decap_12
X_440_ _915_/Q VSUBS VSUBS _999_/VPB _999_/VPB _440_/Y sky130_fd_sc_hd__clkinv_1
XFILLER_9_206 VSUBS VSUBS _999_/VPB _999_/VPB sky130_fd_sc_hd__decap_12
XFILLER_9_239 VSUBS VSUBS _999_/VPB _999_/VPB sky130_fd_sc_hd__fill_1
XFILLER_13_257 VSUBS VSUBS _999_/VPB _999_/VPB sky130_fd_sc_hd__decap_8
XFILLER_13_268 VSUBS VSUBS _999_/VPB _999_/VPB sky130_fd_sc_hd__decap_12
XFILLER_36_327 VSUBS VSUBS _999_/VPB _999_/VPB sky130_fd_sc_hd__decap_3
X_707_ _541_/X _682_/Y _509_/Y VSUBS VSUBS _999_/VPB _999_/VPB _722_/S sky130_fd_sc_hd__a21oi_1
XFILLER_51_319 VSUBS VSUBS _999_/VPB _999_/VPB sky130_fd_sc_hd__decap_12
X_569_ _882_/Q _562_/X _587_/C VSUBS VSUBS _999_/VPB _999_/VPB _569_/Y sky130_fd_sc_hd__o21ai_0
X_638_ _638_/A _638_/B VSUBS VSUBS _999_/VPB _999_/VPB _898_/D sky130_fd_sc_hd__nor2_1
XFILLER_8_250 VSUBS VSUBS _999_/VPB _999_/VPB sky130_fd_sc_hd__decap_12
XFILLER_8_283 VSUBS VSUBS _999_/VPB _999_/VPB sky130_fd_sc_hd__decap_12
XFILLER_39_121 VSUBS VSUBS _999_/VPB _999_/VPB sky130_fd_sc_hd__decap_12
XFILLER_5_61 VSUBS VSUBS _999_/VPB _999_/VPB sky130_fd_sc_hd__decap_12
XFILLER_54_179 VSUBS VSUBS _999_/VPB _999_/VPB sky130_fd_sc_hd__decap_12
XFILLER_49_12 VSUBS VSUBS _999_/VPB _999_/VPB sky130_fd_sc_hd__decap_12
XTAP_TAPCELL_ROW_14_92 VSUBS _999_/VPB sky130_fd_sc_hd__tapvpwrvgnd_1
XFILLER_60_127 VSUBS VSUBS _999_/VPB _999_/VPB sky130_fd_sc_hd__decap_12
XFILLER_5_253 VSUBS VSUBS _999_/VPB _999_/VPB sky130_fd_sc_hd__decap_12
XFILLER_30_91 VSUBS VSUBS _999_/VPB _999_/VPB sky130_fd_sc_hd__decap_12
XFILLER_5_286 VSUBS VSUBS _999_/VPB _999_/VPB sky130_fd_sc_hd__decap_12
XFILLER_19_48 VSUBS VSUBS _999_/VPB _999_/VPB sky130_fd_sc_hd__decap_12
XFILLER_42_127 VSUBS VSUBS _999_/VPB _999_/VPB sky130_fd_sc_hd__decap_12
XFILLER_35_36 VSUBS VSUBS _999_/VPB _999_/VPB sky130_fd_sc_hd__decap_12
XFILLER_15_319 VSUBS VSUBS _999_/VPB _999_/VPB sky130_fd_sc_hd__decap_12
XFILLER_51_24 VSUBS VSUBS _999_/VPB _999_/VPB sky130_fd_sc_hd__decap_12
XFILLER_2_223 VSUBS VSUBS _999_/VPB _999_/VPB sky130_fd_sc_hd__decap_6
X_972_ _983_/CLK _972_/D VSUBS VSUBS _999_/VPB _999_/VPB _972_/Q sky130_fd_sc_hd__dfxtp_1
XFILLER_58_271 VSUBS VSUBS _999_/VPB _999_/VPB sky130_fd_sc_hd__decap_3
XTAP_TAPCELL_ROW_28_174 VSUBS _999_/VPB sky130_fd_sc_hd__tapvpwrvgnd_1
XFILLER_24_127 VSUBS VSUBS _999_/VPB _999_/VPB sky130_fd_sc_hd__decap_12
XFILLER_20_344 VSUBS VSUBS _999_/VPB _999_/VPB sky130_fd_sc_hd__decap_6
XFILLER_20_366 VSUBS VSUBS _999_/VPB _999_/VPB sky130_fd_sc_hd__decap_3
XFILLER_55_241 VSUBS VSUBS _999_/VPB _999_/VPB sky130_fd_sc_hd__decap_12
XFILLER_46_79 VSUBS VSUBS _999_/VPB _999_/VPB sky130_fd_sc_hd__decap_8
XFILLER_46_24 VSUBS VSUBS _999_/VPB _999_/VPB sky130_fd_sc_hd__decap_6
XFILLER_15_127 VSUBS VSUBS _999_/VPB _999_/VPB sky130_fd_sc_hd__fill_1
XFILLER_2_0 VSUBS VSUBS _999_/VPB _999_/VPB sky130_fd_sc_hd__decap_12
XFILLER_7_337 VSUBS VSUBS _999_/VPB _999_/VPB sky130_fd_sc_hd__decap_4
X_955_ _959_/CLK _955_/D VSUBS VSUBS _999_/VPB _999_/VPB _955_/Q sky130_fd_sc_hd__dfxtp_1
X_886_ _969_/CLK _886_/D VSUBS VSUBS _999_/VPB _999_/VPB _886_/Q sky130_fd_sc_hd__dfxtp_1
XFILLER_61_211 VSUBS VSUBS _999_/VPB _999_/VPB sky130_fd_sc_hd__decap_12
XTAP_TAPCELL_ROW_7_50 VSUBS _999_/VPB sky130_fd_sc_hd__tapvpwrvgnd_1
XFILLER_61_299 VSUBS VSUBS _999_/VPB _999_/VPB sky130_fd_sc_hd__fill_1
XTAP_TAPCELL_ROW_0_5 VSUBS _999_/VPB sky130_fd_sc_hd__tapvpwrvgnd_1
XFILLER_14_193 VSUBS VSUBS _999_/VPB _999_/VPB sky130_fd_sc_hd__decap_12
XFILLER_35_0 VSUBS VSUBS _999_/VPB _999_/VPB sky130_fd_sc_hd__decap_12
XFILLER_37_274 VSUBS VSUBS _999_/VPB _999_/VPB sky130_fd_sc_hd__fill_2
XFILLER_37_241 VSUBS VSUBS _999_/VPB _999_/VPB sky130_fd_sc_hd__decap_12
XFILLER_52_222 VSUBS VSUBS _999_/VPB _999_/VPB sky130_fd_sc_hd__decap_12
XFILLER_52_211 VSUBS VSUBS _999_/VPB _999_/VPB sky130_fd_sc_hd__decap_6
XTAP_TAPCELL_ROW_47_291 VSUBS _999_/VPB sky130_fd_sc_hd__tapvpwrvgnd_1
XTAP_TAPCELL_ROW_30_191 VSUBS _999_/VPB sky130_fd_sc_hd__tapvpwrvgnd_1
XFILLER_20_163 VSUBS VSUBS _999_/VPB _999_/VPB sky130_fd_sc_hd__fill_2
XFILLER_57_12 VSUBS VSUBS _999_/VPB _999_/VPB sky130_fd_sc_hd__decap_12
X_740_ _759_/S _738_/Y _739_/Y VSUBS VSUBS _999_/VPB _999_/VPB _930_/D sky130_fd_sc_hd__a21oi_1
X_671_ _949_/Q _662_/Y _459_/B VSUBS VSUBS _999_/VPB _999_/VPB _671_/Y sky130_fd_sc_hd__o21ai_0
XFILLER_7_145 VSUBS VSUBS _999_/VPB _999_/VPB sky130_fd_sc_hd__decap_12
XFILLER_3_340 VSUBS VSUBS _999_/VPB _999_/VPB sky130_fd_sc_hd__fill_1
X_869_ _828_/A _861_/B _866_/Y _868_/Y VSUBS VSUBS _999_/VPB _999_/VPB _974_/D sky130_fd_sc_hd__o22ai_1
X_938_ _983_/CLK _938_/D VSUBS VSUBS _999_/VPB _999_/VPB _938_/Q sky130_fd_sc_hd__dfxtp_1
XFILLER_19_241 VSUBS VSUBS _999_/VPB _999_/VPB sky130_fd_sc_hd__decap_8
XTAP_TAPCELL_ROW_44_272 VSUBS _999_/VPB sky130_fd_sc_hd__tapvpwrvgnd_1
XFILLER_57_336 VSUBS VSUBS _999_/VPB _999_/VPB sky130_fd_sc_hd__fill_2
XFILLER_25_200 VSUBS VSUBS _999_/VPB _999_/VPB sky130_fd_sc_hd__fill_1
XFILLER_25_244 VSUBS VSUBS _999_/VPB _999_/VPB sky130_fd_sc_hd__fill_1
XFILLER_27_48 VSUBS VSUBS _999_/VPB _999_/VPB sky130_fd_sc_hd__decap_12
XFILLER_4_115 VSUBS VSUBS _999_/VPB _999_/VPB sky130_fd_sc_hd__decap_12
Xspare_nand2_1 spare_nand2_1/A spare_nand2_1/B VSUBS VSUBS _999_/VPB _999_/VPB spare_nand2_1/Y
+ sky130_fd_sc_hd__nand2_1
X_654_ LAST_CMD[5] _659_/B VSUBS VSUBS _999_/VPB _999_/VPB _656_/A sky130_fd_sc_hd__nor2_1
X_723_ _723_/A _723_/B VSUBS VSUBS _999_/VPB _999_/VPB _927_/D sky130_fd_sc_hd__nor2_1
XFILLER_0_343 VSUBS VSUBS _999_/VPB _999_/VPB sky130_fd_sc_hd__decap_12
XTAP_TAPCELL_ROW_33_209 VSUBS _999_/VPB sky130_fd_sc_hd__tapvpwrvgnd_1
X_585_ _888_/Q _578_/C _578_/Y _943_/Q VSUBS VSUBS _999_/VPB _999_/VPB _586_/B sky130_fd_sc_hd__a22oi_1
XFILLER_16_244 VSUBS VSUBS _999_/VPB _999_/VPB sky130_fd_sc_hd__decap_4
XTAP_TAPCELL_ROW_41_253 VSUBS _999_/VPB sky130_fd_sc_hd__tapvpwrvgnd_1
XFILLER_31_269 VSUBS VSUBS _999_/VPB _999_/VPB sky130_fd_sc_hd__decap_3
XFILLER_39_325 VSUBS VSUBS _999_/VPB _999_/VPB sky130_fd_sc_hd__decap_12
XFILLER_3_181 VSUBS VSUBS _999_/VPB _999_/VPB sky130_fd_sc_hd__decap_12
XFILLER_39_358 VSUBS VSUBS _999_/VPB _999_/VPB sky130_fd_sc_hd__fill_2
XFILLER_30_291 VSUBS VSUBS _999_/VPB _999_/VPB sky130_fd_sc_hd__decap_12
XFILLER_22_247 VSUBS VSUBS _999_/VPB _999_/VPB sky130_fd_sc_hd__decap_12
XFILLER_57_133 VSUBS VSUBS _999_/VPB _999_/VPB sky130_fd_sc_hd__decap_6
XFILLER_45_306 VSUBS VSUBS _999_/VPB _999_/VPB sky130_fd_sc_hd__decap_4
XFILLER_54_79 VSUBS VSUBS _999_/VPB _999_/VPB sky130_fd_sc_hd__decap_8
XFILLER_54_24 VSUBS VSUBS _999_/VPB _999_/VPB sky130_fd_sc_hd__decap_6
XFILLER_53_361 VSUBS VSUBS _999_/VPB _999_/VPB sky130_fd_sc_hd__decap_8
XFILLER_45_339 VSUBS VSUBS _999_/VPB _999_/VPB sky130_fd_sc_hd__decap_12
XFILLER_9_218 VSUBS VSUBS _999_/VPB _999_/VPB sky130_fd_sc_hd__decap_4
XFILLER_0_151 VSUBS VSUBS _999_/VPB _999_/VPB sky130_fd_sc_hd__decap_12
X_637_ _897_/Q _896_/Q _629_/Y _898_/Q VSUBS VSUBS _999_/VPB _999_/VPB _638_/B sky130_fd_sc_hd__a31oi_1
X_706_ _723_/A _706_/B _706_/C VSUBS VSUBS _999_/VPB _999_/VPB _919_/D sky130_fd_sc_hd__nor3_1
XFILLER_28_91 VSUBS VSUBS _999_/VPB _999_/VPB sky130_fd_sc_hd__decap_12
XFILLER_44_361 VSUBS VSUBS _999_/VPB _999_/VPB sky130_fd_sc_hd__decap_8
X_499_ _458_/Y _496_/Y _498_/Y VSUBS VSUBS _999_/VPB _999_/VPB _980_/D sky130_fd_sc_hd__o21ai_0
X_568_ _547_/B _566_/Y _567_/Y _565_/Y VSUBS VSUBS _999_/VPB _999_/VPB _881_/D sky130_fd_sc_hd__a31oi_1
XFILLER_5_73 VSUBS VSUBS _999_/VPB _999_/VPB sky130_fd_sc_hd__decap_12
XFILLER_8_262 VSUBS VSUBS _999_/VPB _999_/VPB sky130_fd_sc_hd__fill_1
XFILLER_8_295 VSUBS VSUBS _999_/VPB _999_/VPB sky130_fd_sc_hd__decap_12
XFILLER_39_177 VSUBS VSUBS _999_/VPB _999_/VPB sky130_fd_sc_hd__decap_3
XFILLER_39_133 VSUBS VSUBS _999_/VPB _999_/VPB sky130_fd_sc_hd__decap_12
XFILLER_54_147 VSUBS VSUBS _999_/VPB _999_/VPB sky130_fd_sc_hd__decap_3
XFILLER_54_103 VSUBS VSUBS _999_/VPB _999_/VPB sky130_fd_sc_hd__decap_12
XFILLER_50_342 VSUBS VSUBS _999_/VPB _999_/VPB sky130_fd_sc_hd__decap_12
XFILLER_50_331 VSUBS VSUBS _999_/VPB _999_/VPB sky130_fd_sc_hd__decap_6
XFILLER_35_361 VSUBS VSUBS _999_/VPB _999_/VPB sky130_fd_sc_hd__decap_8
XTAP_TAPCELL_ROW_60_370 VSUBS _999_/VPB sky130_fd_sc_hd__tapvpwrvgnd_1
XFILLER_49_24 VSUBS VSUBS _999_/VPB _999_/VPB sky130_fd_sc_hd__decap_12
XTAP_TAPCELL_ROW_14_93 VSUBS _999_/VPB sky130_fd_sc_hd__tapvpwrvgnd_1
XFILLER_18_317 VSUBS VSUBS _999_/VPB _999_/VPB sky130_fd_sc_hd__decap_3
XFILLER_60_139 VSUBS VSUBS _999_/VPB _999_/VPB sky130_fd_sc_hd__decap_8
XFILLER_5_298 VSUBS VSUBS _999_/VPB _999_/VPB sky130_fd_sc_hd__fill_2
XFILLER_5_265 VSUBS VSUBS _999_/VPB _999_/VPB sky130_fd_sc_hd__decap_3
XFILLER_5_221 VSUBS VSUBS _999_/VPB _999_/VPB sky130_fd_sc_hd__fill_1
XFILLER_51_117 VSUBS VSUBS _999_/VPB _999_/VPB sky130_fd_sc_hd__decap_3
XFILLER_44_191 VSUBS VSUBS _999_/VPB _999_/VPB sky130_fd_sc_hd__decap_12
XFILLER_36_147 VSUBS VSUBS _999_/VPB _999_/VPB sky130_fd_sc_hd__decap_3
XFILLER_36_103 VSUBS VSUBS _999_/VPB _999_/VPB sky130_fd_sc_hd__decap_12
XFILLER_32_331 VSUBS VSUBS _999_/VPB _999_/VPB sky130_fd_sc_hd__decap_12
XFILLER_17_361 VSUBS VSUBS _999_/VPB _999_/VPB sky130_fd_sc_hd__decap_8
XFILLER_51_36 VSUBS VSUBS _999_/VPB _999_/VPB sky130_fd_sc_hd__decap_12
XFILLER_42_139 VSUBS VSUBS _999_/VPB _999_/VPB sky130_fd_sc_hd__fill_1
XFILLER_35_48 VSUBS VSUBS _999_/VPB _999_/VPB sky130_fd_sc_hd__decap_12
X_971_ _983_/CLK _971_/D VSUBS VSUBS _999_/VPB _999_/VPB _971_/Q sky130_fd_sc_hd__dfxtp_1
XFILLER_33_117 VSUBS VSUBS _999_/VPB _999_/VPB sky130_fd_sc_hd__decap_3
XFILLER_14_331 VSUBS VSUBS _999_/VPB _999_/VPB sky130_fd_sc_hd__decap_12
XFILLER_18_103 VSUBS VSUBS _999_/VPB _999_/VPB sky130_fd_sc_hd__decap_12
XFILLER_26_180 VSUBS VSUBS _999_/VPB _999_/VPB sky130_fd_sc_hd__decap_3
XTAP_TAPCELL_ROW_28_175 VSUBS _999_/VPB sky130_fd_sc_hd__tapvpwrvgnd_1
XFILLER_41_194 VSUBS VSUBS _999_/VPB _999_/VPB sky130_fd_sc_hd__decap_12
XFILLER_14_353 VSUBS VSUBS _999_/VPB _999_/VPB sky130_fd_sc_hd__decap_12
XTAP_TAPCELL_ROW_19_120 VSUBS _999_/VPB sky130_fd_sc_hd__tapvpwrvgnd_1
XFILLER_24_139 VSUBS VSUBS _999_/VPB _999_/VPB sky130_fd_sc_hd__decap_8
XFILLER_55_253 VSUBS VSUBS _999_/VPB _999_/VPB sky130_fd_sc_hd__decap_12
XTAP_TAPCELL_ROW_11_72 VSUBS _999_/VPB sky130_fd_sc_hd__tapvpwrvgnd_1
XFILLER_15_117 VSUBS VSUBS _999_/VPB _999_/VPB sky130_fd_sc_hd__decap_3
XFILLER_11_301 VSUBS VSUBS _999_/VPB _999_/VPB sky130_fd_sc_hd__decap_12
XTAP_TAPCELL_ROW_25_156 VSUBS _999_/VPB sky130_fd_sc_hd__tapvpwrvgnd_1
XFILLER_11_61 VSUBS VSUBS _999_/VPB _999_/VPB sky130_fd_sc_hd__decap_12
X_954_ _959_/CLK _954_/D VSUBS VSUBS _999_/VPB _999_/VPB _954_/Q sky130_fd_sc_hd__dfxtp_1
X_885_ _969_/CLK _885_/D VSUBS VSUBS _999_/VPB _999_/VPB _885_/Q sky130_fd_sc_hd__dfxtp_1
XFILLER_61_223 VSUBS VSUBS _999_/VPB _999_/VPB sky130_fd_sc_hd__decap_12
XFILLER_36_91 VSUBS VSUBS _999_/VPB _999_/VPB sky130_fd_sc_hd__decap_12
XTAP_TAPCELL_ROW_7_51 VSUBS _999_/VPB sky130_fd_sc_hd__tapvpwrvgnd_1
XFILLER_21_109 VSUBS VSUBS _999_/VPB _999_/VPB sky130_fd_sc_hd__decap_8
XTAP_TAPCELL_ROW_0_6 VSUBS _999_/VPB sky130_fd_sc_hd__tapvpwrvgnd_1
XFILLER_28_0 VSUBS VSUBS _999_/VPB _999_/VPB sky130_fd_sc_hd__decap_12
XFILLER_52_234 VSUBS VSUBS _999_/VPB _999_/VPB sky130_fd_sc_hd__decap_12
XFILLER_37_253 VSUBS VSUBS _999_/VPB _999_/VPB sky130_fd_sc_hd__decap_4
XFILLER_52_256 VSUBS VSUBS _999_/VPB _999_/VPB sky130_fd_sc_hd__decap_3
XTAP_TAPCELL_ROW_47_292 VSUBS _999_/VPB sky130_fd_sc_hd__tapvpwrvgnd_1
XFILLER_20_175 VSUBS VSUBS _999_/VPB _999_/VPB sky130_fd_sc_hd__decap_6
XFILLER_20_186 VSUBS VSUBS _999_/VPB _999_/VPB sky130_fd_sc_hd__decap_12
XFILLER_57_24 VSUBS VSUBS _999_/VPB _999_/VPB sky130_fd_sc_hd__decap_12
X_670_ _444_/Y _662_/Y _669_/Y VSUBS VSUBS _999_/VPB _999_/VPB _911_/D sky130_fd_sc_hd__a21oi_1
XFILLER_43_278 VSUBS VSUBS _999_/VPB _999_/VPB sky130_fd_sc_hd__fill_2
XFILLER_7_157 VSUBS VSUBS _999_/VPB _999_/VPB sky130_fd_sc_hd__decap_12
X_868_ _974_/Q _873_/B VSUBS VSUBS _999_/VPB _999_/VPB _868_/Y sky130_fd_sc_hd__nand2_1
X_799_ _828_/A _799_/B VSUBS VSUBS _999_/VPB _999_/VPB _942_/D sky130_fd_sc_hd__nor2_1
X_937_ _969_/CLK _937_/D VSUBS VSUBS _999_/VPB _999_/VPB _937_/Q sky130_fd_sc_hd__dfxtp_1
XTAP_TAPCELL_ROW_44_273 VSUBS _999_/VPB sky130_fd_sc_hd__tapvpwrvgnd_1
XFILLER_57_348 VSUBS VSUBS _999_/VPB _999_/VPB sky130_fd_sc_hd__decap_12
XFILLER_4_127 VSUBS VSUBS _999_/VPB _999_/VPB sky130_fd_sc_hd__decap_12
XFILLER_0_355 VSUBS VSUBS _999_/VPB _999_/VPB sky130_fd_sc_hd__decap_4
XTAP_TAPCELL_ROW_58_354 VSUBS _999_/VPB sky130_fd_sc_hd__tapvpwrvgnd_1
X_722_ _927_/Q _952_/Q _722_/S VSUBS VSUBS _999_/VPB _999_/VPB _723_/B sky130_fd_sc_hd__mux2i_1
X_653_ _439_/Y _659_/B _652_/Y _723_/A VSUBS VSUBS _999_/VPB _999_/VPB _904_/D sky130_fd_sc_hd__a211oi_1
XTAP_TAPCELL_ROW_41_254 VSUBS _999_/VPB sky130_fd_sc_hd__tapvpwrvgnd_1
XFILLER_31_237 VSUBS VSUBS _999_/VPB _999_/VPB sky130_fd_sc_hd__decap_3
X_584_ _723_/A _584_/B VSUBS VSUBS _999_/VPB _999_/VPB _887_/D sky130_fd_sc_hd__nor2_1
XTAP_TAPCELL_ROW_4_30 VSUBS _999_/VPB sky130_fd_sc_hd__tapvpwrvgnd_1
XFILLER_39_337 VSUBS VSUBS _999_/VPB _999_/VPB sky130_fd_sc_hd__decap_8
XFILLER_3_193 VSUBS VSUBS _999_/VPB _999_/VPB sky130_fd_sc_hd__fill_2
XFILLER_22_259 VSUBS VSUBS _999_/VPB _999_/VPB sky130_fd_sc_hd__decap_8
XFILLER_57_167 VSUBS VSUBS _999_/VPB _999_/VPB sky130_fd_sc_hd__fill_2
XFILLER_0_163 VSUBS VSUBS _999_/VPB _999_/VPB sky130_fd_sc_hd__decap_12
XFILLER_36_307 VSUBS VSUBS _999_/VPB _999_/VPB sky130_fd_sc_hd__decap_12
X_567_ _765_/C _578_/C VSUBS VSUBS _999_/VPB _999_/VPB _567_/Y sky130_fd_sc_hd__nor2_1
X_636_ _636_/A _636_/B VSUBS VSUBS _999_/VPB _999_/VPB _897_/D sky130_fd_sc_hd__nor2_1
X_705_ _703_/A _703_/B CH_ENABLE[0] VSUBS VSUBS _999_/VPB _999_/VPB _706_/C sky130_fd_sc_hd__a21oi_1
XFILLER_44_91 VSUBS VSUBS _999_/VPB _999_/VPB sky130_fd_sc_hd__decap_12
X_498_ _980_/Q _504_/B VSUBS VSUBS _999_/VPB _999_/VPB _498_/Y sky130_fd_sc_hd__nand2_1
XFILLER_5_85 VSUBS VSUBS _999_/VPB _999_/VPB sky130_fd_sc_hd__decap_12
XFILLER_54_115 VSUBS VSUBS _999_/VPB _999_/VPB sky130_fd_sc_hd__decap_12
XFILLER_39_145 VSUBS VSUBS _999_/VPB _999_/VPB sky130_fd_sc_hd__decap_12
XFILLER_10_0 VSUBS VSUBS _999_/VPB _999_/VPB sky130_fd_sc_hd__decap_12
XFILLER_50_354 VSUBS VSUBS _999_/VPB _999_/VPB sky130_fd_sc_hd__decap_12
XTAP_TAPCELL_ROW_60_371 VSUBS _999_/VPB sky130_fd_sc_hd__tapvpwrvgnd_1
XFILLER_49_36 VSUBS VSUBS _999_/VPB _999_/VPB sky130_fd_sc_hd__decap_12
XTAP_TAPCELL_ROW_14_94 VSUBS _999_/VPB sky130_fd_sc_hd__tapvpwrvgnd_1
XFILLER_41_354 VSUBS VSUBS _999_/VPB _999_/VPB sky130_fd_sc_hd__decap_6
XFILLER_36_115 VSUBS VSUBS _999_/VPB _999_/VPB sky130_fd_sc_hd__decap_12
XFILLER_32_354 VSUBS VSUBS _999_/VPB _999_/VPB sky130_fd_sc_hd__decap_12
XFILLER_32_343 VSUBS VSUBS _999_/VPB _999_/VPB sky130_fd_sc_hd__decap_8
XFILLER_32_321 VSUBS VSUBS _999_/VPB _999_/VPB sky130_fd_sc_hd__fill_1
X_619_ _893_/Q _618_/Y _622_/C VSUBS VSUBS _999_/VPB _999_/VPB _620_/B sky130_fd_sc_hd__mux2i_1
XFILLER_58_0 VSUBS VSUBS _999_/VPB _999_/VPB sky130_fd_sc_hd__decap_12
XFILLER_51_48 VSUBS VSUBS _999_/VPB _999_/VPB sky130_fd_sc_hd__decap_12
XFILLER_35_181 VSUBS VSUBS _999_/VPB _999_/VPB sky130_fd_sc_hd__decap_12
X_970_ _970_/CLK _970_/D VSUBS VSUBS _999_/VPB _999_/VPB _970_/Q sky130_fd_sc_hd__dfxtp_1
XFILLER_18_115 VSUBS VSUBS _999_/VPB _999_/VPB sky130_fd_sc_hd__decap_12
XFILLER_14_343 VSUBS VSUBS _999_/VPB _999_/VPB sky130_fd_sc_hd__fill_2
XFILLER_14_365 VSUBS VSUBS _999_/VPB _999_/VPB sky130_fd_sc_hd__decap_4
XTAP_TAPCELL_ROW_28_176 VSUBS _999_/VPB sky130_fd_sc_hd__tapvpwrvgnd_1
XFILLER_2_31 VSUBS VSUBS _999_/VPB _999_/VPB sky130_fd_sc_hd__decap_12
XTAP_TAPCELL_ROW_19_121 VSUBS _999_/VPB sky130_fd_sc_hd__tapvpwrvgnd_1
XFILLER_32_151 VSUBS VSUBS _999_/VPB _999_/VPB sky130_fd_sc_hd__decap_12
XFILLER_17_181 VSUBS VSUBS _999_/VPB _999_/VPB sky130_fd_sc_hd__decap_12
XTAP_TAPCELL_ROW_11_73 VSUBS _999_/VPB sky130_fd_sc_hd__tapvpwrvgnd_1
XFILLER_55_265 VSUBS VSUBS _999_/VPB _999_/VPB sky130_fd_sc_hd__decap_12
XTAP_TAPCELL_ROW_25_157 VSUBS _999_/VPB sky130_fd_sc_hd__tapvpwrvgnd_1
XFILLER_11_313 VSUBS VSUBS _999_/VPB _999_/VPB sky130_fd_sc_hd__decap_8
X_953_ _959_/CLK _953_/D VSUBS VSUBS _999_/VPB _999_/VPB _953_/Q sky130_fd_sc_hd__dfxtp_1
XFILLER_11_73 VSUBS VSUBS _999_/VPB _999_/VPB sky130_fd_sc_hd__decap_12
X_884_ _970_/CLK _884_/D VSUBS VSUBS _999_/VPB _999_/VPB _884_/Q sky130_fd_sc_hd__dfxtp_1
XFILLER_61_235 VSUBS VSUBS _999_/VPB _999_/VPB sky130_fd_sc_hd__decap_4
XTAP_TAPCELL_ROW_7_52 VSUBS _999_/VPB sky130_fd_sc_hd__tapvpwrvgnd_1
XFILLER_14_151 VSUBS VSUBS _999_/VPB _999_/VPB sky130_fd_sc_hd__decap_12
XTAP_TAPCELL_ROW_16_102 VSUBS _999_/VPB sky130_fd_sc_hd__tapvpwrvgnd_1
XFILLER_52_91 VSUBS VSUBS _999_/VPB _999_/VPB sky130_fd_sc_hd__decap_12
XTAP_TAPCELL_ROW_0_7 VSUBS _999_/VPB sky130_fd_sc_hd__tapvpwrvgnd_1
XFILLER_6_350 VSUBS VSUBS _999_/VPB _999_/VPB sky130_fd_sc_hd__decap_12
XFILLER_52_246 VSUBS VSUBS _999_/VPB _999_/VPB sky130_fd_sc_hd__decap_6
XTAP_TAPCELL_ROW_47_293 VSUBS _999_/VPB sky130_fd_sc_hd__tapvpwrvgnd_1
XFILLER_37_298 VSUBS VSUBS _999_/VPB _999_/VPB sky130_fd_sc_hd__fill_2
XFILLER_20_198 VSUBS VSUBS _999_/VPB _999_/VPB sky130_fd_sc_hd__decap_12
XTAP_TAPCELL_ROW_22_138 VSUBS _999_/VPB sky130_fd_sc_hd__tapvpwrvgnd_1
XFILLER_57_36 VSUBS VSUBS _999_/VPB _999_/VPB sky130_fd_sc_hd__decap_12
XFILLER_11_121 VSUBS VSUBS _999_/VPB _999_/VPB sky130_fd_sc_hd__decap_12
XFILLER_28_298 VSUBS VSUBS _999_/VPB _999_/VPB sky130_fd_sc_hd__decap_12
XFILLER_7_169 VSUBS VSUBS _999_/VPB _999_/VPB sky130_fd_sc_hd__decap_8
XFILLER_11_187 VSUBS VSUBS _999_/VPB _999_/VPB sky130_fd_sc_hd__decap_12
X_936_ _969_/CLK _936_/D VSUBS VSUBS _999_/VPB _999_/VPB _936_/Q sky130_fd_sc_hd__dfxtp_1
X_798_ _942_/Q _788_/A _765_/Y _797_/X VSUBS VSUBS _999_/VPB _999_/VPB _799_/B sky130_fd_sc_hd__a22oi_1
X_867_ _865_/X _866_/Y _864_/A VSUBS VSUBS _999_/VPB _999_/VPB _973_/D sky130_fd_sc_hd__o21ba_1
XTAP_TAPCELL_ROW_44_274 VSUBS _999_/VPB sky130_fd_sc_hd__tapvpwrvgnd_1
XFILLER_34_279 VSUBS VSUBS _999_/VPB _999_/VPB sky130_fd_sc_hd__fill_2
XFILLER_34_268 VSUBS VSUBS _999_/VPB _999_/VPB sky130_fd_sc_hd__fill_2
XFILLER_40_0 VSUBS VSUBS _999_/VPB _999_/VPB sky130_fd_sc_hd__decap_12
XFILLER_40_238 VSUBS VSUBS _999_/VPB _999_/VPB sky130_fd_sc_hd__decap_12
XFILLER_4_139 VSUBS VSUBS _999_/VPB _999_/VPB sky130_fd_sc_hd__decap_8
XFILLER_0_301 VSUBS VSUBS _999_/VPB _999_/VPB sky130_fd_sc_hd__decap_12
XTAP_TAPCELL_ROW_58_355 VSUBS _999_/VPB sky130_fd_sc_hd__tapvpwrvgnd_1
XFILLER_48_327 VSUBS VSUBS _999_/VPB _999_/VPB sky130_fd_sc_hd__decap_3
X_721_ _723_/A _721_/B VSUBS VSUBS _999_/VPB _999_/VPB _926_/D sky130_fd_sc_hd__nor2_1
X_652_ LAST_CMD[4] _659_/B VSUBS VSUBS _999_/VPB _999_/VPB _652_/Y sky130_fd_sc_hd__nor2_1
X_583_ _887_/Q _578_/C _578_/Y _942_/Q VSUBS VSUBS _999_/VPB _999_/VPB _584_/B sky130_fd_sc_hd__a22oi_1
XFILLER_17_61 VSUBS VSUBS _999_/VPB _999_/VPB sky130_fd_sc_hd__decap_12
XTAP_TAPCELL_ROW_41_255 VSUBS _999_/VPB sky130_fd_sc_hd__tapvpwrvgnd_1
XFILLER_31_205 VSUBS VSUBS _999_/VPB _999_/VPB sky130_fd_sc_hd__decap_12
XTAP_TAPCELL_ROW_4_31 VSUBS _999_/VPB sky130_fd_sc_hd__tapvpwrvgnd_1
XFILLER_16_279 VSUBS VSUBS _999_/VPB _999_/VPB sky130_fd_sc_hd__fill_1
XTAP_TAPCELL_ROW_49_300 VSUBS _999_/VPB sky130_fd_sc_hd__tapvpwrvgnd_1
Xspare_oai_0 spare_oai_0/A1 spare_oai_0/A2 spare_oai_0/B1 VSUBS VSUBS _999_/VPB _999_/VPB
+ spare_oai_0/Y sky130_fd_sc_hd__o21ai_0
X_919_ _970_/CLK _919_/D VSUBS VSUBS _999_/VPB _999_/VPB CH_ENABLE[0] sky130_fd_sc_hd__dfxtp_1
XTAP_TAPCELL_ROW_32_200 VSUBS _999_/VPB sky130_fd_sc_hd__tapvpwrvgnd_1
XFILLER_30_271 VSUBS VSUBS _999_/VPB _999_/VPB sky130_fd_sc_hd__decap_4
XFILLER_30_260 VSUBS VSUBS _999_/VPB _999_/VPB sky130_fd_sc_hd__decap_8
XFILLER_1_109 VSUBS VSUBS _999_/VPB _999_/VPB sky130_fd_sc_hd__decap_8
XTAP_TAPCELL_ROW_55_336 VSUBS _999_/VPB sky130_fd_sc_hd__tapvpwrvgnd_1
X_704_ _945_/Q _978_/Q _703_/Y VSUBS VSUBS _999_/VPB _999_/VPB _706_/B sky130_fd_sc_hd__a21oi_1
XFILLER_0_175 VSUBS VSUBS _999_/VPB _999_/VPB sky130_fd_sc_hd__decap_4
X_566_ _936_/Q _765_/B VSUBS VSUBS _999_/VPB _999_/VPB _566_/Y sky130_fd_sc_hd__nand2_1
X_635_ _897_/Q _629_/Y _873_/B VSUBS VSUBS _999_/VPB _999_/VPB _636_/B sky130_fd_sc_hd__o21ai_0
XFILLER_60_91 VSUBS VSUBS _999_/VPB _999_/VPB sky130_fd_sc_hd__decap_12
X_497_ _944_/Q _828_/A VSUBS VSUBS _999_/VPB _999_/VPB _504_/B sky130_fd_sc_hd__nor2_1
XFILLER_12_271 VSUBS VSUBS _999_/VPB _999_/VPB sky130_fd_sc_hd__decap_6
XFILLER_12_293 VSUBS VSUBS _999_/VPB _999_/VPB sky130_fd_sc_hd__decap_12
XFILLER_5_97 VSUBS VSUBS _999_/VPB _999_/VPB sky130_fd_sc_hd__decap_12
XFILLER_54_127 VSUBS VSUBS _999_/VPB _999_/VPB sky130_fd_sc_hd__decap_12
XFILLER_39_157 VSUBS VSUBS _999_/VPB _999_/VPB sky130_fd_sc_hd__decap_12
XFILLER_50_366 VSUBS VSUBS _999_/VPB _999_/VPB sky130_fd_sc_hd__decap_3
XFILLER_10_208 VSUBS VSUBS _999_/VPB _999_/VPB sky130_fd_sc_hd__fill_2
XFILLER_49_48 VSUBS VSUBS _999_/VPB _999_/VPB sky130_fd_sc_hd__decap_12
XTAP_TAPCELL_ROW_14_95 VSUBS _999_/VPB sky130_fd_sc_hd__tapvpwrvgnd_1
XFILLER_41_333 VSUBS VSUBS _999_/VPB _999_/VPB sky130_fd_sc_hd__decap_12
XFILLER_36_127 VSUBS VSUBS _999_/VPB _999_/VPB sky130_fd_sc_hd__decap_4
XFILLER_17_330 VSUBS VSUBS _999_/VPB _999_/VPB sky130_fd_sc_hd__decap_12
XFILLER_44_182 VSUBS VSUBS _999_/VPB _999_/VPB sky130_fd_sc_hd__decap_3
XFILLER_32_366 VSUBS VSUBS _999_/VPB _999_/VPB sky130_fd_sc_hd__decap_3
X_618_ _893_/Q _981_/Q VSUBS VSUBS _999_/VPB _999_/VPB _618_/Y sky130_fd_sc_hd__nand2_1
XFILLER_17_352 VSUBS VSUBS _999_/VPB _999_/VPB sky130_fd_sc_hd__decap_8
X_549_ _541_/X _548_/Y _540_/Y VSUBS VSUBS _999_/VPB _999_/VPB _549_/Y sky130_fd_sc_hd__o21ai_0
XFILLER_35_171 VSUBS VSUBS _999_/VPB _999_/VPB sky130_fd_sc_hd__decap_8
XFILLER_35_193 VSUBS VSUBS _999_/VPB _999_/VPB sky130_fd_sc_hd__decap_8
XFILLER_18_127 VSUBS VSUBS _999_/VPB _999_/VPB sky130_fd_sc_hd__decap_12
XFILLER_25_61 VSUBS VSUBS _999_/VPB _999_/VPB sky130_fd_sc_hd__decap_12
XTAP_TAPCELL_ROW_28_177 VSUBS _999_/VPB sky130_fd_sc_hd__tapvpwrvgnd_1
XFILLER_49_241 VSUBS VSUBS _999_/VPB _999_/VPB sky130_fd_sc_hd__decap_3
XFILLER_2_43 VSUBS VSUBS _999_/VPB _999_/VPB sky130_fd_sc_hd__decap_12
XFILLER_2_87 VSUBS VSUBS _999_/VPB _999_/VPB sky130_fd_sc_hd__decap_3
XTAP_TAPCELL_ROW_19_122 VSUBS _999_/VPB sky130_fd_sc_hd__tapvpwrvgnd_1
XFILLER_32_163 VSUBS VSUBS _999_/VPB _999_/VPB sky130_fd_sc_hd__decap_12
XFILLER_20_336 VSUBS VSUBS _999_/VPB _999_/VPB sky130_fd_sc_hd__decap_4
XTAP_TAPCELL_ROW_11_74 VSUBS _999_/VPB sky130_fd_sc_hd__tapvpwrvgnd_1
XFILLER_55_299 VSUBS VSUBS _999_/VPB _999_/VPB sky130_fd_sc_hd__fill_1
XFILLER_55_277 VSUBS VSUBS _999_/VPB _999_/VPB sky130_fd_sc_hd__decap_12
XFILLER_23_163 VSUBS VSUBS _999_/VPB _999_/VPB sky130_fd_sc_hd__fill_1
XTAP_TAPCELL_ROW_25_158 VSUBS _999_/VPB sky130_fd_sc_hd__tapvpwrvgnd_1
X_952_ _978_/CLK _959_/Q _461_/X VSUBS VSUBS _999_/VPB _999_/VPB _952_/Q sky130_fd_sc_hd__edfxtp_1
XFILLER_11_85 VSUBS VSUBS _999_/VPB _999_/VPB sky130_fd_sc_hd__decap_12
X_883_ _970_/CLK _883_/D VSUBS VSUBS _999_/VPB _999_/VPB _883_/Q sky130_fd_sc_hd__dfxtp_1
XFILLER_46_299 VSUBS VSUBS _999_/VPB _999_/VPB sky130_fd_sc_hd__fill_2
XFILLER_46_211 VSUBS VSUBS _999_/VPB _999_/VPB sky130_fd_sc_hd__decap_12
XTAP_TAPCELL_ROW_16_103 VSUBS _999_/VPB sky130_fd_sc_hd__tapvpwrvgnd_1
XFILLER_61_269 VSUBS VSUBS _999_/VPB _999_/VPB sky130_fd_sc_hd__fill_1
XTAP_TAPCELL_ROW_7_53 VSUBS _999_/VPB sky130_fd_sc_hd__tapvpwrvgnd_1
XFILLER_14_163 VSUBS VSUBS _999_/VPB _999_/VPB sky130_fd_sc_hd__decap_12
XTAP_TAPCELL_ROW_0_8 VSUBS _999_/VPB sky130_fd_sc_hd__tapvpwrvgnd_1
XFILLER_6_362 VSUBS VSUBS _999_/VPB _999_/VPB sky130_fd_sc_hd__decap_6
XFILLER_20_144 VSUBS VSUBS _999_/VPB _999_/VPB sky130_fd_sc_hd__fill_2
XFILLER_20_155 VSUBS VSUBS _999_/VPB _999_/VPB sky130_fd_sc_hd__decap_8
XTAP_TAPCELL_ROW_22_139 VSUBS _999_/VPB sky130_fd_sc_hd__tapvpwrvgnd_1
XFILLER_57_48 VSUBS VSUBS _999_/VPB _999_/VPB sky130_fd_sc_hd__decap_12
XFILLER_43_203 VSUBS VSUBS _999_/VPB _999_/VPB sky130_fd_sc_hd__decap_12
XFILLER_28_211 VSUBS VSUBS _999_/VPB _999_/VPB sky130_fd_sc_hd__decap_12
XFILLER_11_133 VSUBS VSUBS _999_/VPB _999_/VPB sky130_fd_sc_hd__decap_12
XFILLER_11_199 VSUBS VSUBS _999_/VPB _999_/VPB sky130_fd_sc_hd__decap_12
X_935_ _982_/CLK _935_/D VSUBS VSUBS _999_/VPB _999_/VPB _935_/Q sky130_fd_sc_hd__dfxtp_1
XFILLER_0_0 VSUBS VSUBS _999_/VPB _999_/VPB sky130_fd_sc_hd__decap_12
X_866_ _973_/Q _972_/Q _863_/B VSUBS VSUBS _999_/VPB _999_/VPB _866_/Y sky130_fd_sc_hd__nor3b_1
XFILLER_19_222 VSUBS VSUBS _999_/VPB _999_/VPB sky130_fd_sc_hd__decap_12
X_797_ _797_/A _797_/B VSUBS VSUBS _999_/VPB _999_/VPB _797_/X sky130_fd_sc_hd__xor2_1
XFILLER_19_255 VSUBS VSUBS _999_/VPB _999_/VPB sky130_fd_sc_hd__decap_12
XFILLER_19_299 VSUBS VSUBS _999_/VPB _999_/VPB sky130_fd_sc_hd__fill_1
XTAP_TAPCELL_ROW_44_275 VSUBS _999_/VPB sky130_fd_sc_hd__tapvpwrvgnd_1
XFILLER_8_31 VSUBS VSUBS _999_/VPB _999_/VPB sky130_fd_sc_hd__decap_12
XFILLER_33_0 VSUBS VSUBS _999_/VPB _999_/VPB sky130_fd_sc_hd__decap_12
XFILLER_43_28 VSUBS VSUBS _999_/VPB _999_/VPB sky130_fd_sc_hd__decap_12
XTAP_TAPCELL_ROW_35_220 VSUBS _999_/VPB sky130_fd_sc_hd__tapvpwrvgnd_1
X_720_ _926_/Q _951_/Q _722_/S VSUBS VSUBS _999_/VPB _999_/VPB _721_/B sky130_fd_sc_hd__mux2i_1
XFILLER_0_313 VSUBS VSUBS _999_/VPB _999_/VPB sky130_fd_sc_hd__decap_12
XTAP_TAPCELL_ROW_58_356 VSUBS _999_/VPB sky130_fd_sc_hd__tapvpwrvgnd_1
X_651_ _651_/A _651_/B VSUBS VSUBS _999_/VPB _999_/VPB _903_/D sky130_fd_sc_hd__nor2_1
XFILLER_31_217 VSUBS VSUBS _999_/VPB _999_/VPB sky130_fd_sc_hd__decap_12
X_582_ _723_/A _582_/B VSUBS VSUBS _999_/VPB _999_/VPB _886_/D sky130_fd_sc_hd__nor2_1
XFILLER_16_269 VSUBS VSUBS _999_/VPB _999_/VPB sky130_fd_sc_hd__fill_1
XFILLER_17_73 VSUBS VSUBS _999_/VPB _999_/VPB sky130_fd_sc_hd__decap_12
XTAP_TAPCELL_ROW_41_256 VSUBS _999_/VPB sky130_fd_sc_hd__tapvpwrvgnd_1
XFILLER_33_61 VSUBS VSUBS _999_/VPB _999_/VPB sky130_fd_sc_hd__decap_12
XTAP_TAPCELL_ROW_4_32 VSUBS _999_/VPB sky130_fd_sc_hd__tapvpwrvgnd_1
XFILLER_58_91 VSUBS VSUBS _999_/VPB _999_/VPB sky130_fd_sc_hd__decap_12
XTAP_TAPCELL_ROW_49_301 VSUBS _999_/VPB sky130_fd_sc_hd__tapvpwrvgnd_1
XFILLER_47_361 VSUBS VSUBS _999_/VPB _999_/VPB sky130_fd_sc_hd__decap_8
X_918_ _970_/CLK _918_/D VSUBS VSUBS _999_/VPB _999_/VPB CH_ENABLE[1] sky130_fd_sc_hd__dfxtp_1
X_849_ _886_/Q _967_/Q _861_/B VSUBS VSUBS _999_/VPB _999_/VPB _849_/Y sky130_fd_sc_hd__mux2i_1
XTAP_TAPCELL_ROW_32_201 VSUBS _999_/VPB sky130_fd_sc_hd__tapvpwrvgnd_1
XFILLER_15_291 VSUBS VSUBS _999_/VPB _999_/VPB sky130_fd_sc_hd__decap_8
XTAP_TAPCELL_ROW_55_337 VSUBS _999_/VPB sky130_fd_sc_hd__tapvpwrvgnd_1
XFILLER_0_121 VSUBS VSUBS _999_/VPB _999_/VPB sky130_fd_sc_hd__decap_12
XFILLER_48_147 VSUBS VSUBS _999_/VPB _999_/VPB sky130_fd_sc_hd__decap_3
XFILLER_48_103 VSUBS VSUBS _999_/VPB _999_/VPB sky130_fd_sc_hd__decap_12
XFILLER_29_361 VSUBS VSUBS _999_/VPB _999_/VPB sky130_fd_sc_hd__decap_8
X_634_ _554_/A _633_/X _639_/C VSUBS VSUBS _999_/VPB _999_/VPB _636_/A sky130_fd_sc_hd__a21oi_1
X_703_ _703_/A _703_/B VSUBS VSUBS _999_/VPB _999_/VPB _703_/Y sky130_fd_sc_hd__nand2_1
XFILLER_44_331 VSUBS VSUBS _999_/VPB _999_/VPB sky130_fd_sc_hd__decap_8
X_496_ _495_/A _495_/B _976_/Q VSUBS VSUBS _999_/VPB _999_/VPB _496_/Y sky130_fd_sc_hd__o21ai_0
X_565_ _881_/Q _562_/X _587_/C VSUBS VSUBS _999_/VPB _999_/VPB _565_/Y sky130_fd_sc_hd__o21ai_0
XFILLER_54_139 VSUBS VSUBS _999_/VPB _999_/VPB sky130_fd_sc_hd__decap_8
XFILLER_39_169 VSUBS VSUBS _999_/VPB _999_/VPB sky130_fd_sc_hd__decap_8
XTAP_TAPCELL_ROW_52_318 VSUBS _999_/VPB sky130_fd_sc_hd__tapvpwrvgnd_1
XFILLER_45_117 VSUBS VSUBS _999_/VPB _999_/VPB sky130_fd_sc_hd__decap_3
XFILLER_41_345 VSUBS VSUBS _999_/VPB _999_/VPB sky130_fd_sc_hd__decap_6
XFILLER_41_301 VSUBS VSUBS _999_/VPB _999_/VPB sky130_fd_sc_hd__decap_8
XFILLER_26_331 VSUBS VSUBS _999_/VPB _999_/VPB sky130_fd_sc_hd__decap_3
XFILLER_51_109 VSUBS VSUBS _999_/VPB _999_/VPB sky130_fd_sc_hd__decap_8
XFILLER_17_342 VSUBS VSUBS _999_/VPB _999_/VPB sky130_fd_sc_hd__fill_2
X_617_ _977_/Q _538_/B _616_/Y VSUBS VSUBS _999_/VPB _999_/VPB _622_/C sky130_fd_sc_hd__a21oi_1
X_479_ LAST_CMD[1] _479_/B VSUBS VSUBS _999_/VPB _999_/VPB _541_/B sky130_fd_sc_hd__nand2_1
X_548_ CH_ENABLE[1] _540_/B _542_/Y VSUBS VSUBS _999_/VPB _999_/VPB _548_/Y sky130_fd_sc_hd__a21oi_1
XFILLER_27_117 VSUBS VSUBS _999_/VPB _999_/VPB sky130_fd_sc_hd__decap_3
XFILLER_23_301 VSUBS VSUBS _999_/VPB _999_/VPB sky130_fd_sc_hd__decap_12
XFILLER_50_197 VSUBS VSUBS _999_/VPB _999_/VPB sky130_fd_sc_hd__fill_2
XFILLER_2_249 VSUBS VSUBS _999_/VPB _999_/VPB sky130_fd_sc_hd__decap_12
XFILLER_33_109 VSUBS VSUBS _999_/VPB _999_/VPB sky130_fd_sc_hd__decap_8
XFILLER_18_139 VSUBS VSUBS _999_/VPB _999_/VPB sky130_fd_sc_hd__fill_1
XFILLER_25_73 VSUBS VSUBS _999_/VPB _999_/VPB sky130_fd_sc_hd__decap_12
XTAP_TAPCELL_ROW_28_178 VSUBS _999_/VPB sky130_fd_sc_hd__tapvpwrvgnd_1
XFILLER_41_61 VSUBS VSUBS _999_/VPB _999_/VPB sky130_fd_sc_hd__decap_12
XFILLER_2_55 VSUBS VSUBS _999_/VPB _999_/VPB sky130_fd_sc_hd__decap_12
XFILLER_17_150 VSUBS VSUBS _999_/VPB _999_/VPB sky130_fd_sc_hd__decap_12
XTAP_TAPCELL_ROW_19_123 VSUBS _999_/VPB sky130_fd_sc_hd__tapvpwrvgnd_1
XFILLER_32_186 VSUBS VSUBS _999_/VPB _999_/VPB sky130_fd_sc_hd__decap_12
XFILLER_32_175 VSUBS VSUBS _999_/VPB _999_/VPB sky130_fd_sc_hd__decap_6
XFILLER_20_315 VSUBS VSUBS _999_/VPB _999_/VPB sky130_fd_sc_hd__decap_12
XTAP_TAPCELL_ROW_11_75 VSUBS _999_/VPB sky130_fd_sc_hd__tapvpwrvgnd_1
XFILLER_15_109 VSUBS VSUBS _999_/VPB _999_/VPB sky130_fd_sc_hd__decap_8
XTAP_TAPCELL_ROW_25_159 VSUBS _999_/VPB sky130_fd_sc_hd__tapvpwrvgnd_1
XFILLER_11_359 VSUBS VSUBS _999_/VPB _999_/VPB sky130_fd_sc_hd__fill_1
X_951_ _978_/CLK _958_/Q _461_/X VSUBS VSUBS _999_/VPB _999_/VPB _951_/Q sky130_fd_sc_hd__edfxtp_1
XFILLER_11_97 VSUBS VSUBS _999_/VPB _999_/VPB sky130_fd_sc_hd__decap_12
X_882_ _970_/CLK _882_/D VSUBS VSUBS _999_/VPB _999_/VPB _882_/Q sky130_fd_sc_hd__dfxtp_1
XFILLER_46_267 VSUBS VSUBS _999_/VPB _999_/VPB sky130_fd_sc_hd__decap_3
XFILLER_46_223 VSUBS VSUBS _999_/VPB _999_/VPB sky130_fd_sc_hd__decap_12
XTAP_TAPCELL_ROW_16_104 VSUBS _999_/VPB sky130_fd_sc_hd__tapvpwrvgnd_1
XTAP_TAPCELL_ROW_0_9 VSUBS _999_/VPB sky130_fd_sc_hd__tapvpwrvgnd_1
XFILLER_14_175 VSUBS VSUBS _999_/VPB _999_/VPB sky130_fd_sc_hd__decap_6
XFILLER_37_201 VSUBS VSUBS _999_/VPB _999_/VPB sky130_fd_sc_hd__decap_12
XFILLER_43_215 VSUBS VSUBS _999_/VPB _999_/VPB sky130_fd_sc_hd__fill_2
XFILLER_28_223 VSUBS VSUBS _999_/VPB _999_/VPB sky130_fd_sc_hd__decap_12
XFILLER_28_267 VSUBS VSUBS _999_/VPB _999_/VPB sky130_fd_sc_hd__decap_3
Xspare_aoi_0 spare_aoi_0/A1 spare_aoi_0/A2 spare_aoi_0/B1 VSUBS VSUBS _999_/VPB _999_/VPB
+ spare_aoi_0/Y sky130_fd_sc_hd__a21oi_1
XFILLER_11_145 VSUBS VSUBS _999_/VPB _999_/VPB sky130_fd_sc_hd__decap_12
X_934_ _982_/CLK _934_/D VSUBS VSUBS _999_/VPB _999_/VPB _934_/Q sky130_fd_sc_hd__dfxtp_1
X_796_ _828_/A _796_/B VSUBS VSUBS _999_/VPB _999_/VPB _941_/D sky130_fd_sc_hd__nor2_1
X_865_ _972_/Q _971_/Q _859_/B _973_/Q VSUBS VSUBS _999_/VPB _999_/VPB _865_/X sky130_fd_sc_hd__o31a_1
XFILLER_19_234 VSUBS VSUBS _999_/VPB _999_/VPB sky130_fd_sc_hd__decap_6
XFILLER_34_248 VSUBS VSUBS _999_/VPB _999_/VPB sky130_fd_sc_hd__decap_12
XFILLER_19_267 VSUBS VSUBS _999_/VPB _999_/VPB sky130_fd_sc_hd__decap_12
XFILLER_8_43 VSUBS VSUBS _999_/VPB _999_/VPB sky130_fd_sc_hd__decap_12
XFILLER_8_87 VSUBS VSUBS _999_/VPB _999_/VPB sky130_fd_sc_hd__decap_3
XFILLER_26_0 VSUBS VSUBS _999_/VPB _999_/VPB sky130_fd_sc_hd__decap_12
XTAP_TAPCELL_ROW_35_221 VSUBS _999_/VPB sky130_fd_sc_hd__tapvpwrvgnd_1
XFILLER_43_18 VSUBS VSUBS _999_/VPB _999_/VPB sky130_fd_sc_hd__fill_1
XTAP_TAPCELL_ROW_58_357 VSUBS _999_/VPB sky130_fd_sc_hd__tapvpwrvgnd_1
XFILLER_48_307 VSUBS VSUBS _999_/VPB _999_/VPB sky130_fd_sc_hd__decap_12
X_650_ _948_/Q _526_/C _459_/B VSUBS VSUBS _999_/VPB _999_/VPB _651_/B sky130_fd_sc_hd__o21ai_0
XFILLER_0_325 VSUBS VSUBS _999_/VPB _999_/VPB sky130_fd_sc_hd__decap_4
XFILLER_31_229 VSUBS VSUBS _999_/VPB _999_/VPB sky130_fd_sc_hd__decap_8
X_581_ _886_/Q _578_/C _578_/Y _941_/Q VSUBS VSUBS _999_/VPB _999_/VPB _582_/B sky130_fd_sc_hd__a22oi_1
XFILLER_16_215 VSUBS VSUBS _999_/VPB _999_/VPB sky130_fd_sc_hd__decap_12
XFILLER_17_85 VSUBS VSUBS _999_/VPB _999_/VPB sky130_fd_sc_hd__decap_12
XTAP_TAPCELL_ROW_41_257 VSUBS _999_/VPB sky130_fd_sc_hd__tapvpwrvgnd_1
XFILLER_33_73 VSUBS VSUBS _999_/VPB _999_/VPB sky130_fd_sc_hd__decap_12
XTAP_TAPCELL_ROW_4_33 VSUBS _999_/VPB sky130_fd_sc_hd__tapvpwrvgnd_1
XTAP_TAPCELL_ROW_49_302 VSUBS _999_/VPB sky130_fd_sc_hd__tapvpwrvgnd_1
X_917_ _978_/CLK _917_/D VSUBS VSUBS _999_/VPB _999_/VPB CH_ENABLE[2] sky130_fd_sc_hd__dfxtp_1
X_848_ _833_/Y _846_/Y _847_/Y VSUBS VSUBS _999_/VPB _999_/VPB _967_/D sky130_fd_sc_hd__a21oi_1
X_779_ _938_/Q _788_/A _765_/Y _778_/Y VSUBS VSUBS _999_/VPB _999_/VPB _780_/B sky130_fd_sc_hd__a22oi_1
XTAP_TAPCELL_ROW_32_202 VSUBS _999_/VPB sky130_fd_sc_hd__tapvpwrvgnd_1
XTAP_TAPCELL_ROW_55_338 VSUBS _999_/VPB sky130_fd_sc_hd__tapvpwrvgnd_1
XFILLER_13_229 VSUBS VSUBS _999_/VPB _999_/VPB sky130_fd_sc_hd__fill_1
XFILLER_0_133 VSUBS VSUBS _999_/VPB _999_/VPB sky130_fd_sc_hd__decap_12
XFILLER_56_192 VSUBS VSUBS _999_/VPB _999_/VPB sky130_fd_sc_hd__decap_4
XFILLER_48_115 VSUBS VSUBS _999_/VPB _999_/VPB sky130_fd_sc_hd__decap_12
X_702_ _680_/Y _701_/Y _978_/Q VSUBS VSUBS _999_/VPB _999_/VPB _703_/B sky130_fd_sc_hd__o21ai_0
X_633_ _897_/Q _896_/Q VSUBS VSUBS _999_/VPB _999_/VPB _633_/X sky130_fd_sc_hd__xor2_1
X_495_ _495_/A _495_/B VSUBS VSUBS _999_/VPB _999_/VPB _495_/Y sky130_fd_sc_hd__nor2_1
XFILLER_8_211 VSUBS VSUBS _999_/VPB _999_/VPB sky130_fd_sc_hd__decap_12
X_564_ _723_/A _578_/C VSUBS VSUBS _999_/VPB _999_/VPB _880_/D sky130_fd_sc_hd__nor2_1
XTAP_TAPCELL_ROW_52_319 VSUBS _999_/VPB sky130_fd_sc_hd__tapvpwrvgnd_1
XFILLER_47_181 VSUBS VSUBS _999_/VPB _999_/VPB sky130_fd_sc_hd__decap_12
XFILLER_35_354 VSUBS VSUBS _999_/VPB _999_/VPB sky130_fd_sc_hd__decap_6
XFILLER_14_31 VSUBS VSUBS _999_/VPB _999_/VPB sky130_fd_sc_hd__decap_12
XTAP_TAPCELL_ROW_1_12 VSUBS _999_/VPB sky130_fd_sc_hd__tapvpwrvgnd_1
XFILLER_39_61 VSUBS VSUBS _999_/VPB _999_/VPB sky130_fd_sc_hd__decap_12
XFILLER_44_151 VSUBS VSUBS _999_/VPB _999_/VPB sky130_fd_sc_hd__decap_12
XFILLER_32_313 VSUBS VSUBS _999_/VPB _999_/VPB sky130_fd_sc_hd__decap_8
X_547_ _559_/A _547_/B VSUBS VSUBS _999_/VPB _999_/VPB _876_/D sky130_fd_sc_hd__nor2_1
X_616_ _895_/Q _613_/Y _615_/Y VSUBS VSUBS _999_/VPB _999_/VPB _616_/Y sky130_fd_sc_hd__o21ai_0
XFILLER_29_170 VSUBS VSUBS _999_/VPB _999_/VPB sky130_fd_sc_hd__decap_8
XFILLER_29_181 VSUBS VSUBS _999_/VPB _999_/VPB sky130_fd_sc_hd__decap_8
X_478_ _478_/A _478_/B VSUBS VSUBS _999_/VPB _999_/VPB _478_/Y sky130_fd_sc_hd__nand2_1
XFILLER_23_313 VSUBS VSUBS _999_/VPB _999_/VPB sky130_fd_sc_hd__decap_12
XFILLER_23_357 VSUBS VSUBS _999_/VPB _999_/VPB sky130_fd_sc_hd__decap_3
XFILLER_50_176 VSUBS VSUBS _999_/VPB _999_/VPB sky130_fd_sc_hd__fill_1
XFILLER_2_239 VSUBS VSUBS _999_/VPB _999_/VPB sky130_fd_sc_hd__decap_3
XFILLER_26_151 VSUBS VSUBS _999_/VPB _999_/VPB sky130_fd_sc_hd__fill_1
XTAP_TAPCELL_ROW_28_179 VSUBS _999_/VPB sky130_fd_sc_hd__tapvpwrvgnd_1
XFILLER_41_121 VSUBS VSUBS _999_/VPB _999_/VPB sky130_fd_sc_hd__decap_12
XFILLER_25_85 VSUBS VSUBS _999_/VPB _999_/VPB sky130_fd_sc_hd__decap_12
XFILLER_41_73 VSUBS VSUBS _999_/VPB _999_/VPB sky130_fd_sc_hd__decap_12
XFILLER_49_276 VSUBS VSUBS _999_/VPB _999_/VPB sky130_fd_sc_hd__decap_3
XFILLER_49_221 VSUBS VSUBS _999_/VPB _999_/VPB sky130_fd_sc_hd__decap_12
XFILLER_2_67 VSUBS VSUBS _999_/VPB _999_/VPB sky130_fd_sc_hd__decap_12
XFILLER_2_12 VSUBS VSUBS _999_/VPB _999_/VPB sky130_fd_sc_hd__decap_12
XFILLER_17_162 VSUBS VSUBS _999_/VPB _999_/VPB sky130_fd_sc_hd__decap_12
XTAP_TAPCELL_ROW_19_124 VSUBS _999_/VPB sky130_fd_sc_hd__tapvpwrvgnd_1
XFILLER_32_198 VSUBS VSUBS _999_/VPB _999_/VPB sky130_fd_sc_hd__decap_12
XFILLER_9_361 VSUBS VSUBS _999_/VPB _999_/VPB sky130_fd_sc_hd__decap_8
XFILLER_20_327 VSUBS VSUBS _999_/VPB _999_/VPB sky130_fd_sc_hd__decap_3
XFILLER_56_0 VSUBS VSUBS _999_/VPB _999_/VPB sky130_fd_sc_hd__decap_12
XFILLER_55_235 VSUBS VSUBS _999_/VPB _999_/VPB sky130_fd_sc_hd__decap_4
XTAP_TAPCELL_ROW_11_76 VSUBS _999_/VPB sky130_fd_sc_hd__tapvpwrvgnd_1
XFILLER_23_121 VSUBS VSUBS _999_/VPB _999_/VPB sky130_fd_sc_hd__decap_12
X_950_ _959_/CLK _957_/Q _461_/X VSUBS VSUBS _999_/VPB _999_/VPB _950_/Q sky130_fd_sc_hd__edfxtp_1
XFILLER_46_202 VSUBS VSUBS _999_/VPB _999_/VPB sky130_fd_sc_hd__decap_8
X_881_ _970_/CLK _881_/D VSUBS VSUBS _999_/VPB _999_/VPB _881_/Q sky130_fd_sc_hd__dfxtp_1
XFILLER_61_205 VSUBS VSUBS _999_/VPB _999_/VPB sky130_fd_sc_hd__decap_4
XFILLER_46_235 VSUBS VSUBS _999_/VPB _999_/VPB sky130_fd_sc_hd__decap_12
XTAP_TAPCELL_ROW_16_105 VSUBS _999_/VPB sky130_fd_sc_hd__tapvpwrvgnd_1
XFILLER_6_331 VSUBS VSUBS _999_/VPB _999_/VPB sky130_fd_sc_hd__decap_12
XFILLER_37_257 VSUBS VSUBS _999_/VPB _999_/VPB sky130_fd_sc_hd__fill_1
XFILLER_37_213 VSUBS VSUBS _999_/VPB _999_/VPB sky130_fd_sc_hd__decap_12
XFILLER_60_271 VSUBS VSUBS _999_/VPB _999_/VPB sky130_fd_sc_hd__decap_12
XFILLER_20_168 VSUBS VSUBS _999_/VPB _999_/VPB sky130_fd_sc_hd__fill_2
XFILLER_28_235 VSUBS VSUBS _999_/VPB _999_/VPB sky130_fd_sc_hd__decap_12
XFILLER_7_117 VSUBS VSUBS _999_/VPB _999_/VPB sky130_fd_sc_hd__decap_3
XFILLER_11_157 VSUBS VSUBS _999_/VPB _999_/VPB sky130_fd_sc_hd__decap_12
XFILLER_22_31 VSUBS VSUBS _999_/VPB _999_/VPB sky130_fd_sc_hd__decap_12
X_933_ _933_/CLK _933_/D VSUBS VSUBS _999_/VPB _999_/VPB _933_/Q sky130_fd_sc_hd__dfxtp_1
XFILLER_3_301 VSUBS VSUBS _999_/VPB _999_/VPB sky130_fd_sc_hd__decap_6
XFILLER_47_61 VSUBS VSUBS _999_/VPB _999_/VPB sky130_fd_sc_hd__decap_12
X_795_ _941_/Q _788_/A _765_/Y _794_/Y VSUBS VSUBS _999_/VPB _999_/VPB _796_/B sky130_fd_sc_hd__a22oi_1
X_864_ _864_/A _864_/B VSUBS VSUBS _999_/VPB _999_/VPB _972_/D sky130_fd_sc_hd__nor2_1
XFILLER_19_279 VSUBS VSUBS _999_/VPB _999_/VPB sky130_fd_sc_hd__decap_12
Xclkbuf_3_4__f_clk clkbuf_0_clk/X VSUBS VSUBS _999_/VPB _999_/VPB _982_/CLK sky130_fd_sc_hd__clkbuf_16
XFILLER_8_55 VSUBS VSUBS _999_/VPB _999_/VPB sky130_fd_sc_hd__decap_12
XFILLER_40_208 VSUBS VSUBS _999_/VPB _999_/VPB sky130_fd_sc_hd__fill_2
XFILLER_19_0 VSUBS VSUBS _999_/VPB _999_/VPB sky130_fd_sc_hd__decap_12
XFILLER_25_238 VSUBS VSUBS _999_/VPB _999_/VPB sky130_fd_sc_hd__fill_2
XFILLER_33_260 VSUBS VSUBS _999_/VPB _999_/VPB sky130_fd_sc_hd__decap_6
XTAP_TAPCELL_ROW_58_358 VSUBS _999_/VPB sky130_fd_sc_hd__tapvpwrvgnd_1
XFILLER_48_319 VSUBS VSUBS _999_/VPB _999_/VPB sky130_fd_sc_hd__decap_8
XFILLER_0_359 VSUBS VSUBS _999_/VPB _999_/VPB sky130_fd_sc_hd__fill_1
X_580_ _723_/A _580_/B VSUBS VSUBS _999_/VPB _999_/VPB _885_/D sky130_fd_sc_hd__nor2_1
XFILLER_17_97 VSUBS VSUBS _999_/VPB _999_/VPB sky130_fd_sc_hd__decap_12
XFILLER_24_271 VSUBS VSUBS _999_/VPB _999_/VPB sky130_fd_sc_hd__decap_8
XFILLER_33_85 VSUBS VSUBS _999_/VPB _999_/VPB sky130_fd_sc_hd__decap_12
XTAP_TAPCELL_ROW_4_34 VSUBS _999_/VPB sky130_fd_sc_hd__tapvpwrvgnd_1
XTAP_TAPCELL_ROW_49_303 VSUBS _999_/VPB sky130_fd_sc_hd__tapvpwrvgnd_1
X_916_ _970_/CLK _916_/D VSUBS VSUBS _999_/VPB _999_/VPB CH_ENABLE[3] sky130_fd_sc_hd__dfxtp_1
X_847_ _967_/Q _833_/Y _587_/C VSUBS VSUBS _999_/VPB _999_/VPB _847_/Y sky130_fd_sc_hd__o21ai_0
X_778_ _778_/A _781_/B VSUBS VSUBS _999_/VPB _999_/VPB _778_/Y sky130_fd_sc_hd__xnor2_1
XTAP_TAPCELL_ROW_32_203 VSUBS _999_/VPB sky130_fd_sc_hd__tapvpwrvgnd_1
XTAP_TAPCELL_ROW_55_339 VSUBS _999_/VPB sky130_fd_sc_hd__tapvpwrvgnd_1
XFILLER_21_241 VSUBS VSUBS _999_/VPB _999_/VPB sky130_fd_sc_hd__decap_12
XFILLER_0_145 VSUBS VSUBS _999_/VPB _999_/VPB sky130_fd_sc_hd__decap_4
XFILLER_48_127 VSUBS VSUBS _999_/VPB _999_/VPB sky130_fd_sc_hd__decap_12
X_701_ _924_/Q _701_/B VSUBS VSUBS _999_/VPB _999_/VPB _701_/Y sky130_fd_sc_hd__nand2_1
X_563_ _981_/Q _627_/B _464_/B VSUBS VSUBS _999_/VPB _999_/VPB _578_/C sky130_fd_sc_hd__o21ai_0
X_632_ _638_/A _632_/B VSUBS VSUBS _999_/VPB _999_/VPB _896_/D sky130_fd_sc_hd__nor2_1
X_494_ _950_/Q _947_/Q _946_/Q _945_/Q VSUBS VSUBS _999_/VPB _999_/VPB _495_/B sky130_fd_sc_hd__nand4_1
XFILLER_8_223 VSUBS VSUBS _999_/VPB _999_/VPB sky130_fd_sc_hd__decap_8
XFILLER_5_12 VSUBS VSUBS _999_/VPB _999_/VPB sky130_fd_sc_hd__decap_12
XFILLER_47_193 VSUBS VSUBS _999_/VPB _999_/VPB sky130_fd_sc_hd__fill_2
XFILLER_26_311 VSUBS VSUBS _999_/VPB _999_/VPB sky130_fd_sc_hd__fill_1
XFILLER_53_152 VSUBS VSUBS _999_/VPB _999_/VPB sky130_fd_sc_hd__decap_12
XFILLER_14_43 VSUBS VSUBS _999_/VPB _999_/VPB sky130_fd_sc_hd__decap_12
XFILLER_14_87 VSUBS VSUBS _999_/VPB _999_/VPB sky130_fd_sc_hd__decap_3
XFILLER_26_366 VSUBS VSUBS _999_/VPB _999_/VPB sky130_fd_sc_hd__decap_3
XFILLER_30_31 VSUBS VSUBS _999_/VPB _999_/VPB sky130_fd_sc_hd__decap_12
XTAP_TAPCELL_ROW_1_13 VSUBS _999_/VPB sky130_fd_sc_hd__tapvpwrvgnd_1
XFILLER_39_73 VSUBS VSUBS _999_/VPB _999_/VPB sky130_fd_sc_hd__decap_12
XFILLER_55_61 VSUBS VSUBS _999_/VPB _999_/VPB sky130_fd_sc_hd__decap_12
XFILLER_44_163 VSUBS VSUBS _999_/VPB _999_/VPB sky130_fd_sc_hd__decap_12
X_546_ _979_/Q _538_/Y _544_/Y _554_/A VSUBS VSUBS _999_/VPB _999_/VPB _547_/B sky130_fd_sc_hd__a22oi_1
X_615_ _975_/Q _981_/Q _512_/B _614_/Y VSUBS VSUBS _999_/VPB _999_/VPB _615_/Y sky130_fd_sc_hd__a211oi_1
XFILLER_29_193 VSUBS VSUBS _999_/VPB _999_/VPB sky130_fd_sc_hd__fill_1
X_477_ LAST_CMD[2] LAST_CMD[1] LAST_CMD[3] VSUBS VSUBS _999_/VPB _999_/VPB _478_/B
+ sky130_fd_sc_hd__a21oi_1
XFILLER_4_281 VSUBS VSUBS _999_/VPB _999_/VPB sky130_fd_sc_hd__decap_12
XFILLER_50_188 VSUBS VSUBS _999_/VPB _999_/VPB sky130_fd_sc_hd__decap_4
XFILLER_50_133 VSUBS VSUBS _999_/VPB _999_/VPB sky130_fd_sc_hd__fill_1
XFILLER_23_325 VSUBS VSUBS _999_/VPB _999_/VPB sky130_fd_sc_hd__decap_12
XFILLER_2_207 VSUBS VSUBS _999_/VPB _999_/VPB sky130_fd_sc_hd__decap_3
XFILLER_58_211 VSUBS VSUBS _999_/VPB _999_/VPB sky130_fd_sc_hd__decap_12
XFILLER_41_133 VSUBS VSUBS _999_/VPB _999_/VPB sky130_fd_sc_hd__decap_12
XFILLER_25_97 VSUBS VSUBS _999_/VPB _999_/VPB sky130_fd_sc_hd__decap_12
XFILLER_41_85 VSUBS VSUBS _999_/VPB _999_/VPB sky130_fd_sc_hd__decap_12
XFILLER_49_299 VSUBS VSUBS _999_/VPB _999_/VPB sky130_fd_sc_hd__fill_1
XFILLER_49_233 VSUBS VSUBS _999_/VPB _999_/VPB sky130_fd_sc_hd__decap_6
XFILLER_2_79 VSUBS VSUBS _999_/VPB _999_/VPB sky130_fd_sc_hd__decap_8
XFILLER_2_24 VSUBS VSUBS _999_/VPB _999_/VPB sky130_fd_sc_hd__decap_6
XTAP_TAPCELL_ROW_19_125 VSUBS _999_/VPB sky130_fd_sc_hd__tapvpwrvgnd_1
X_529_ _723_/A _529_/B VSUBS VSUBS _999_/VPB _999_/VPB _874_/D sky130_fd_sc_hd__nor2_1
XFILLER_17_174 VSUBS VSUBS _999_/VPB _999_/VPB sky130_fd_sc_hd__decap_6
XFILLER_49_0 VSUBS VSUBS _999_/VPB _999_/VPB sky130_fd_sc_hd__decap_12
XTAP_TAPCELL_ROW_11_77 VSUBS _999_/VPB sky130_fd_sc_hd__tapvpwrvgnd_1
XFILLER_23_133 VSUBS VSUBS _999_/VPB _999_/VPB sky130_fd_sc_hd__decap_12
XFILLER_46_247 VSUBS VSUBS _999_/VPB _999_/VPB sky130_fd_sc_hd__decap_12
X_880_ _969_/CLK _880_/D VSUBS VSUBS _999_/VPB _999_/VPB _880_/Q sky130_fd_sc_hd__dfxtp_1
XFILLER_61_239 VSUBS VSUBS _999_/VPB _999_/VPB sky130_fd_sc_hd__fill_1
XTAP_TAPCELL_ROW_16_106 VSUBS _999_/VPB sky130_fd_sc_hd__tapvpwrvgnd_1
XTAP_TAPCELL_ROW_24_150 VSUBS _999_/VPB sky130_fd_sc_hd__tapvpwrvgnd_1
XFILLER_6_343 VSUBS VSUBS _999_/VPB _999_/VPB sky130_fd_sc_hd__decap_3
XFILLER_52_217 VSUBS VSUBS _999_/VPB _999_/VPB sky130_fd_sc_hd__fill_1
XFILLER_37_225 VSUBS VSUBS _999_/VPB _999_/VPB sky130_fd_sc_hd__decap_12
XFILLER_60_283 VSUBS VSUBS _999_/VPB _999_/VPB sky130_fd_sc_hd__decap_12
XFILLER_20_103 VSUBS VSUBS _999_/VPB _999_/VPB sky130_fd_sc_hd__decap_12
XTAP_TAPCELL_ROW_30_186 VSUBS _999_/VPB sky130_fd_sc_hd__tapvpwrvgnd_1
XFILLER_28_247 VSUBS VSUBS _999_/VPB _999_/VPB sky130_fd_sc_hd__decap_12
XFILLER_43_239 VSUBS VSUBS _999_/VPB _999_/VPB sky130_fd_sc_hd__fill_1
XFILLER_51_294 VSUBS VSUBS _999_/VPB _999_/VPB sky130_fd_sc_hd__fill_2
XFILLER_11_169 VSUBS VSUBS _999_/VPB _999_/VPB sky130_fd_sc_hd__decap_4
XFILLER_22_43 VSUBS VSUBS _999_/VPB _999_/VPB sky130_fd_sc_hd__decap_12
XFILLER_22_87 VSUBS VSUBS _999_/VPB _999_/VPB sky130_fd_sc_hd__decap_3
X_932_ _933_/CLK _932_/D VSUBS VSUBS _999_/VPB _999_/VPB _932_/Q sky130_fd_sc_hd__dfxtp_1
XFILLER_3_357 VSUBS VSUBS _999_/VPB _999_/VPB sky130_fd_sc_hd__decap_3
XFILLER_3_324 VSUBS VSUBS _999_/VPB _999_/VPB sky130_fd_sc_hd__decap_12
X_863_ _972_/Q _863_/B VSUBS VSUBS _999_/VPB _999_/VPB _864_/B sky130_fd_sc_hd__xnor2_1
XFILLER_59_361 VSUBS VSUBS _999_/VPB _999_/VPB sky130_fd_sc_hd__decap_8
XFILLER_47_73 VSUBS VSUBS _999_/VPB _999_/VPB sky130_fd_sc_hd__decap_12
XFILLER_34_206 VSUBS VSUBS _999_/VPB _999_/VPB sky130_fd_sc_hd__fill_1
X_794_ _794_/A _797_/B VSUBS VSUBS _999_/VPB _999_/VPB _794_/Y sky130_fd_sc_hd__xnor2_1
XFILLER_27_280 VSUBS VSUBS _999_/VPB _999_/VPB sky130_fd_sc_hd__decap_8
XFILLER_8_12 VSUBS VSUBS _999_/VPB _999_/VPB sky130_fd_sc_hd__decap_12
XFILLER_8_67 VSUBS VSUBS _999_/VPB _999_/VPB sky130_fd_sc_hd__decap_12
XFILLER_6_151 VSUBS VSUBS _999_/VPB _999_/VPB sky130_fd_sc_hd__decap_12
XFILLER_57_309 VSUBS VSUBS _999_/VPB _999_/VPB sky130_fd_sc_hd__decap_3
XFILLER_33_294 VSUBS VSUBS _999_/VPB _999_/VPB sky130_fd_sc_hd__decap_6
XTAP_TAPCELL_ROW_58_359 VSUBS _999_/VPB sky130_fd_sc_hd__tapvpwrvgnd_1
XFILLER_56_331 VSUBS VSUBS _999_/VPB _999_/VPB sky130_fd_sc_hd__decap_8
XFILLER_16_239 VSUBS VSUBS _999_/VPB _999_/VPB sky130_fd_sc_hd__fill_2
XTAP_TAPCELL_ROW_4_35 VSUBS _999_/VPB sky130_fd_sc_hd__tapvpwrvgnd_1
XFILLER_33_97 VSUBS VSUBS _999_/VPB _999_/VPB sky130_fd_sc_hd__decap_12
XFILLER_3_121 VSUBS VSUBS _999_/VPB _999_/VPB sky130_fd_sc_hd__decap_12
XTAP_TAPCELL_ROW_49_304 VSUBS _999_/VPB sky130_fd_sc_hd__tapvpwrvgnd_1
X_915_ _982_/CLK _915_/D VSUBS VSUBS _999_/VPB _999_/VPB _915_/Q sky130_fd_sc_hd__dfxtp_1
XFILLER_3_198 VSUBS VSUBS _999_/VPB _999_/VPB sky130_fd_sc_hd__decap_12
X_846_ _885_/Q _966_/Q _861_/B VSUBS VSUBS _999_/VPB _999_/VPB _846_/Y sky130_fd_sc_hd__mux2i_1
X_777_ _940_/Q _777_/B VSUBS VSUBS _999_/VPB _999_/VPB _781_/B sky130_fd_sc_hd__xnor2_1
XFILLER_30_231 VSUBS VSUBS _999_/VPB _999_/VPB sky130_fd_sc_hd__fill_2
XFILLER_15_283 VSUBS VSUBS _999_/VPB _999_/VPB sky130_fd_sc_hd__decap_3
XFILLER_31_0 VSUBS VSUBS _999_/VPB _999_/VPB sky130_fd_sc_hd__decap_12
XFILLER_57_139 VSUBS VSUBS _999_/VPB _999_/VPB sky130_fd_sc_hd__fill_1
XFILLER_57_117 VSUBS VSUBS _999_/VPB _999_/VPB sky130_fd_sc_hd__decap_3
XFILLER_53_301 VSUBS VSUBS _999_/VPB _999_/VPB sky130_fd_sc_hd__decap_12
XFILLER_38_331 VSUBS VSUBS _999_/VPB _999_/VPB sky130_fd_sc_hd__decap_12
XFILLER_13_209 VSUBS VSUBS _999_/VPB _999_/VPB sky130_fd_sc_hd__decap_12
XFILLER_21_231 VSUBS VSUBS _999_/VPB _999_/VPB sky130_fd_sc_hd__decap_8
XFILLER_21_253 VSUBS VSUBS _999_/VPB _999_/VPB sky130_fd_sc_hd__decap_12
XFILLER_21_286 VSUBS VSUBS _999_/VPB _999_/VPB sky130_fd_sc_hd__decap_12
XFILLER_48_139 VSUBS VSUBS _999_/VPB _999_/VPB sky130_fd_sc_hd__decap_8
X_700_ _723_/A _700_/B _700_/C VSUBS VSUBS _999_/VPB _999_/VPB _918_/D sky130_fd_sc_hd__nor3_1
XFILLER_0_179 VSUBS VSUBS _999_/VPB _999_/VPB sky130_fd_sc_hd__fill_1
XFILLER_28_31 VSUBS VSUBS _999_/VPB _999_/VPB sky130_fd_sc_hd__decap_12
X_493_ _952_/Q _951_/Q _949_/Q _948_/Q VSUBS VSUBS _999_/VPB _999_/VPB _495_/A sky130_fd_sc_hd__nand4_1
X_562_ _981_/Q _627_/B _464_/B VSUBS VSUBS _999_/VPB _999_/VPB _562_/X sky130_fd_sc_hd__o21a_1
X_631_ _896_/Q _639_/C VSUBS VSUBS _999_/VPB _999_/VPB _632_/B sky130_fd_sc_hd__xor2_1
XFILLER_5_24 VSUBS VSUBS _999_/VPB _999_/VPB sky130_fd_sc_hd__decap_12
XFILLER_39_117 VSUBS VSUBS _999_/VPB _999_/VPB sky130_fd_sc_hd__decap_3
X_829_ _962_/Q _873_/C _873_/B VSUBS VSUBS _999_/VPB _999_/VPB _829_/Y sky130_fd_sc_hd__o21ai_0
XFILLER_35_301 VSUBS VSUBS _999_/VPB _999_/VPB sky130_fd_sc_hd__decap_12
XFILLER_7_290 VSUBS VSUBS _999_/VPB _999_/VPB sky130_fd_sc_hd__decap_8
XFILLER_53_164 VSUBS VSUBS _999_/VPB _999_/VPB sky130_fd_sc_hd__decap_12
XFILLER_45_109 VSUBS VSUBS _999_/VPB _999_/VPB sky130_fd_sc_hd__decap_8
XFILLER_14_55 VSUBS VSUBS _999_/VPB _999_/VPB sky130_fd_sc_hd__decap_12
XFILLER_30_87 VSUBS VSUBS _999_/VPB _999_/VPB sky130_fd_sc_hd__decap_3
XFILLER_30_43 VSUBS VSUBS _999_/VPB _999_/VPB sky130_fd_sc_hd__decap_12
XFILLER_5_238 VSUBS VSUBS _999_/VPB _999_/VPB sky130_fd_sc_hd__fill_2
XFILLER_5_205 VSUBS VSUBS _999_/VPB _999_/VPB sky130_fd_sc_hd__decap_12
XTAP_TAPCELL_ROW_1_14 VSUBS _999_/VPB sky130_fd_sc_hd__tapvpwrvgnd_1
XFILLER_39_85 VSUBS VSUBS _999_/VPB _999_/VPB sky130_fd_sc_hd__decap_12
XFILLER_17_301 VSUBS VSUBS _999_/VPB _999_/VPB sky130_fd_sc_hd__fill_1
XFILLER_29_161 VSUBS VSUBS _999_/VPB _999_/VPB sky130_fd_sc_hd__fill_2
XFILLER_55_73 VSUBS VSUBS _999_/VPB _999_/VPB sky130_fd_sc_hd__decap_12
X_476_ LAST_CMD[3] LAST_CMD[2] VSUBS VSUBS _999_/VPB _999_/VPB _479_/B sky130_fd_sc_hd__nor2_1
X_614_ _981_/Q _977_/Q VSUBS VSUBS _999_/VPB _999_/VPB _614_/Y sky130_fd_sc_hd__nor2_1
X_545_ _983_/Q _545_/B _545_/C VSUBS VSUBS _999_/VPB _999_/VPB _554_/A sky130_fd_sc_hd__and3_1
XFILLER_4_293 VSUBS VSUBS _999_/VPB _999_/VPB sky130_fd_sc_hd__decap_8
XFILLER_27_109 VSUBS VSUBS _999_/VPB _999_/VPB sky130_fd_sc_hd__decap_8
XFILLER_23_337 VSUBS VSUBS _999_/VPB _999_/VPB sky130_fd_sc_hd__decap_12
XFILLER_58_223 VSUBS VSUBS _999_/VPB _999_/VPB sky130_fd_sc_hd__decap_3
XFILLER_41_145 VSUBS VSUBS _999_/VPB _999_/VPB sky130_fd_sc_hd__decap_12
XFILLER_41_97 VSUBS VSUBS _999_/VPB _999_/VPB sky130_fd_sc_hd__decap_12
XFILLER_49_201 VSUBS VSUBS _999_/VPB _999_/VPB sky130_fd_sc_hd__fill_1
XFILLER_1_241 VSUBS VSUBS _999_/VPB _999_/VPB sky130_fd_sc_hd__decap_12
XFILLER_9_0 VSUBS VSUBS _999_/VPB _999_/VPB sky130_fd_sc_hd__decap_12
X_528_ _950_/Q _439_/Y _526_/Y _527_/Y _524_/Y VSUBS VSUBS _999_/VPB _999_/VPB _529_/B
+ sky130_fd_sc_hd__a41oi_1
X_459_ _978_/Q _459_/B _523_/B VSUBS VSUBS _999_/VPB _999_/VPB _982_/D sky130_fd_sc_hd__and3_1
XTAP_TAPCELL_ROW_27_170 VSUBS _999_/VPB sky130_fd_sc_hd__tapvpwrvgnd_1
XFILLER_23_145 VSUBS VSUBS _999_/VPB _999_/VPB sky130_fd_sc_hd__decap_12
XFILLER_11_12 VSUBS VSUBS _999_/VPB _999_/VPB sky130_fd_sc_hd__decap_12
XFILLER_23_189 VSUBS VSUBS _999_/VPB _999_/VPB sky130_fd_sc_hd__fill_2
XFILLER_46_259 VSUBS VSUBS _999_/VPB _999_/VPB sky130_fd_sc_hd__decap_8
XFILLER_36_31 VSUBS VSUBS _999_/VPB _999_/VPB sky130_fd_sc_hd__decap_12
XFILLER_14_145 VSUBS VSUBS _999_/VPB _999_/VPB sky130_fd_sc_hd__decap_4
XTAP_TAPCELL_ROW_16_107 VSUBS _999_/VPB sky130_fd_sc_hd__tapvpwrvgnd_1
XTAP_TAPCELL_ROW_24_151 VSUBS _999_/VPB sky130_fd_sc_hd__tapvpwrvgnd_1
XFILLER_52_207 VSUBS VSUBS _999_/VPB _999_/VPB sky130_fd_sc_hd__decap_3
XFILLER_37_237 VSUBS VSUBS _999_/VPB _999_/VPB sky130_fd_sc_hd__decap_3
XFILLER_60_295 VSUBS VSUBS _999_/VPB _999_/VPB sky130_fd_sc_hd__decap_12
XTAP_TAPCELL_ROW_30_187 VSUBS _999_/VPB sky130_fd_sc_hd__tapvpwrvgnd_1
XFILLER_20_115 VSUBS VSUBS _999_/VPB _999_/VPB sky130_fd_sc_hd__decap_12
XFILLER_61_0 VSUBS VSUBS _999_/VPB _999_/VPB sky130_fd_sc_hd__decap_12
XFILLER_28_259 VSUBS VSUBS _999_/VPB _999_/VPB sky130_fd_sc_hd__decap_8
XFILLER_3_336 VSUBS VSUBS _999_/VPB _999_/VPB sky130_fd_sc_hd__decap_4
XTAP_TAPCELL_ROW_21_132 VSUBS _999_/VPB sky130_fd_sc_hd__tapvpwrvgnd_1
XFILLER_22_55 VSUBS VSUBS _999_/VPB _999_/VPB sky130_fd_sc_hd__decap_12
X_931_ _933_/CLK _931_/D VSUBS VSUBS _999_/VPB _999_/VPB _931_/Q sky130_fd_sc_hd__dfxtp_1
X_862_ _862_/A _864_/A VSUBS VSUBS _999_/VPB _999_/VPB _971_/D sky130_fd_sc_hd__nor2_1
XFILLER_47_85 VSUBS VSUBS _999_/VPB _999_/VPB sky130_fd_sc_hd__decap_12
X_793_ _797_/B VSUBS VSUBS _999_/VPB _999_/VPB _793_/Y sky130_fd_sc_hd__clkinv_1
XFILLER_8_24 VSUBS VSUBS _999_/VPB _999_/VPB sky130_fd_sc_hd__decap_6
XFILLER_8_79 VSUBS VSUBS _999_/VPB _999_/VPB sky130_fd_sc_hd__decap_8
XFILLER_6_163 VSUBS VSUBS _999_/VPB _999_/VPB sky130_fd_sc_hd__decap_12
XFILLER_56_365 VSUBS VSUBS _999_/VPB _999_/VPB sky130_fd_sc_hd__decap_4
XFILLER_3_177 VSUBS VSUBS _999_/VPB _999_/VPB sky130_fd_sc_hd__decap_3
XFILLER_3_133 VSUBS VSUBS _999_/VPB _999_/VPB sky130_fd_sc_hd__decap_12
XFILLER_59_181 VSUBS VSUBS _999_/VPB _999_/VPB sky130_fd_sc_hd__decap_12
XTAP_TAPCELL_ROW_49_305 VSUBS _999_/VPB sky130_fd_sc_hd__tapvpwrvgnd_1
X_914_ _982_/CLK _914_/D VSUBS VSUBS _999_/VPB _999_/VPB _914_/Q sky130_fd_sc_hd__dfxtp_1
X_776_ _828_/A _776_/B VSUBS VSUBS _999_/VPB _999_/VPB _937_/D sky130_fd_sc_hd__nor2_1
X_845_ _833_/Y _843_/Y _844_/Y VSUBS VSUBS _999_/VPB _999_/VPB _966_/D sky130_fd_sc_hd__a21oi_1
XFILLER_24_0 VSUBS VSUBS _999_/VPB _999_/VPB sky130_fd_sc_hd__decap_12
XFILLER_53_357 VSUBS VSUBS _999_/VPB _999_/VPB sky130_fd_sc_hd__decap_3
XFILLER_53_313 VSUBS VSUBS _999_/VPB _999_/VPB sky130_fd_sc_hd__decap_12
XFILLER_0_91 VSUBS VSUBS _999_/VPB _999_/VPB sky130_fd_sc_hd__decap_12
XFILLER_21_221 VSUBS VSUBS _999_/VPB _999_/VPB sky130_fd_sc_hd__decap_4
XFILLER_21_265 VSUBS VSUBS _999_/VPB _999_/VPB sky130_fd_sc_hd__decap_12
XFILLER_0_103 VSUBS VSUBS _999_/VPB _999_/VPB sky130_fd_sc_hd__decap_12
XFILLER_21_298 VSUBS VSUBS _999_/VPB _999_/VPB sky130_fd_sc_hd__fill_2
X_630_ _554_/A _639_/C _873_/B VSUBS VSUBS _999_/VPB _999_/VPB _638_/A sky130_fd_sc_hd__o21ai_0
XFILLER_28_43 VSUBS VSUBS _999_/VPB _999_/VPB sky130_fd_sc_hd__decap_12
XTAP_TAPCELL_ROW_54_330 VSUBS _999_/VPB sky130_fd_sc_hd__tapvpwrvgnd_1
XFILLER_44_31 VSUBS VSUBS _999_/VPB _999_/VPB sky130_fd_sc_hd__decap_12
X_561_ _983_/Q _979_/Q VSUBS VSUBS _999_/VPB _999_/VPB _627_/B sky130_fd_sc_hd__lpflow_inputiso1p_1
X_492_ _538_/B _491_/Y _489_/Y _488_/Y VSUBS VSUBS _999_/VPB _999_/VPB _981_/D sky130_fd_sc_hd__o211ai_1
XFILLER_28_87 VSUBS VSUBS _999_/VPB _999_/VPB sky130_fd_sc_hd__decap_3
XFILLER_8_203 VSUBS VSUBS _999_/VPB _999_/VPB sky130_fd_sc_hd__decap_6
XFILLER_5_36 VSUBS VSUBS _999_/VPB _999_/VPB sky130_fd_sc_hd__decap_12
XFILLER_47_173 VSUBS VSUBS _999_/VPB _999_/VPB sky130_fd_sc_hd__decap_6
X_759_ _934_/Q _748_/B _759_/S VSUBS VSUBS _999_/VPB _999_/VPB _759_/Y sky130_fd_sc_hd__mux2i_1
X_828_ _828_/A _873_/C _828_/C VSUBS VSUBS _999_/VPB _999_/VPB _961_/D sky130_fd_sc_hd__nor3_1
XFILLER_35_313 VSUBS VSUBS _999_/VPB _999_/VPB sky130_fd_sc_hd__decap_12
XTAP_TAPCELL_ROW_60_366 VSUBS _999_/VPB sky130_fd_sc_hd__tapvpwrvgnd_1
XFILLER_50_316 VSUBS VSUBS _999_/VPB _999_/VPB sky130_fd_sc_hd__decap_12
XFILLER_53_176 VSUBS VSUBS _999_/VPB _999_/VPB sky130_fd_sc_hd__decap_4
XFILLER_53_121 VSUBS VSUBS _999_/VPB _999_/VPB sky130_fd_sc_hd__decap_12
XFILLER_5_217 VSUBS VSUBS _999_/VPB _999_/VPB sky130_fd_sc_hd__decap_4
XFILLER_14_12 VSUBS VSUBS _999_/VPB _999_/VPB sky130_fd_sc_hd__decap_12
XFILLER_14_67 VSUBS VSUBS _999_/VPB _999_/VPB sky130_fd_sc_hd__decap_12
XFILLER_30_55 VSUBS VSUBS _999_/VPB _999_/VPB sky130_fd_sc_hd__decap_12
XTAP_TAPCELL_ROW_1_15 VSUBS _999_/VPB sky130_fd_sc_hd__tapvpwrvgnd_1
XFILLER_39_97 VSUBS VSUBS _999_/VPB _999_/VPB sky130_fd_sc_hd__decap_12
X_613_ _981_/Q _622_/B VSUBS VSUBS _999_/VPB _999_/VPB _613_/Y sky130_fd_sc_hd__nand2_1
XFILLER_55_85 VSUBS VSUBS _999_/VPB _999_/VPB sky130_fd_sc_hd__decap_12
X_475_ LAST_CMD[7] LAST_CMD[6] LAST_CMD[5] LAST_CMD[4] VSUBS VSUBS _999_/VPB _999_/VPB
+ _478_/A sky130_fd_sc_hd__nor4b_1
X_544_ _541_/X _543_/Y _540_/Y VSUBS VSUBS _999_/VPB _999_/VPB _544_/Y sky130_fd_sc_hd__o21ai_0
XFILLER_4_250 VSUBS VSUBS _999_/VPB _999_/VPB sky130_fd_sc_hd__decap_12
XFILLER_35_121 VSUBS VSUBS _999_/VPB _999_/VPB sky130_fd_sc_hd__decap_12
XFILLER_23_349 VSUBS VSUBS _999_/VPB _999_/VPB sky130_fd_sc_hd__decap_8
XFILLER_41_157 VSUBS VSUBS _999_/VPB _999_/VPB sky130_fd_sc_hd__decap_12
XFILLER_14_327 VSUBS VSUBS _999_/VPB _999_/VPB sky130_fd_sc_hd__decap_3
XFILLER_1_253 VSUBS VSUBS _999_/VPB _999_/VPB sky130_fd_sc_hd__decap_12
XFILLER_1_275 VSUBS VSUBS _999_/VPB _999_/VPB sky130_fd_sc_hd__decap_12
XFILLER_57_290 VSUBS VSUBS _999_/VPB _999_/VPB sky130_fd_sc_hd__decap_8
X_527_ _948_/Q _947_/Q _946_/Q _945_/Q VSUBS VSUBS _999_/VPB _999_/VPB _527_/Y sky130_fd_sc_hd__nor4_1
XFILLER_17_121 VSUBS VSUBS _999_/VPB _999_/VPB sky130_fd_sc_hd__decap_12
X_458_ _459_/B _523_/B VSUBS VSUBS _999_/VPB _999_/VPB _458_/Y sky130_fd_sc_hd__nand2_1
XTAP_TAPCELL_ROW_27_171 VSUBS _999_/VPB sky130_fd_sc_hd__tapvpwrvgnd_1
XFILLER_55_205 VSUBS VSUBS _999_/VPB _999_/VPB sky130_fd_sc_hd__decap_12
XFILLER_23_157 VSUBS VSUBS _999_/VPB _999_/VPB sky130_fd_sc_hd__decap_3
XFILLER_23_168 VSUBS VSUBS _999_/VPB _999_/VPB sky130_fd_sc_hd__decap_12
XFILLER_11_24 VSUBS VSUBS _999_/VPB _999_/VPB sky130_fd_sc_hd__decap_12
XFILLER_54_271 VSUBS VSUBS _999_/VPB _999_/VPB sky130_fd_sc_hd__decap_12
XFILLER_36_87 VSUBS VSUBS _999_/VPB _999_/VPB sky130_fd_sc_hd__decap_3
XFILLER_36_43 VSUBS VSUBS _999_/VPB _999_/VPB sky130_fd_sc_hd__decap_12
XFILLER_52_31 VSUBS VSUBS _999_/VPB _999_/VPB sky130_fd_sc_hd__decap_12
XFILLER_6_301 VSUBS VSUBS _999_/VPB _999_/VPB sky130_fd_sc_hd__decap_12
XFILLER_10_352 VSUBS VSUBS _999_/VPB _999_/VPB sky130_fd_sc_hd__decap_12
XTAP_TAPCELL_ROW_24_152 VSUBS _999_/VPB sky130_fd_sc_hd__tapvpwrvgnd_1
XTAP_TAPCELL_ROW_47_288 VSUBS _999_/VPB sky130_fd_sc_hd__tapvpwrvgnd_1
XFILLER_45_282 VSUBS VSUBS _999_/VPB _999_/VPB sky130_fd_sc_hd__decap_12
XTAP_TAPCELL_ROW_30_188 VSUBS _999_/VPB sky130_fd_sc_hd__tapvpwrvgnd_1
XFILLER_9_194 VSUBS VSUBS _999_/VPB _999_/VPB sky130_fd_sc_hd__decap_12
XFILLER_20_127 VSUBS VSUBS _999_/VPB _999_/VPB sky130_fd_sc_hd__fill_1
XFILLER_54_0 VSUBS VSUBS _999_/VPB _999_/VPB sky130_fd_sc_hd__decap_12
XFILLER_36_271 VSUBS VSUBS _999_/VPB _999_/VPB sky130_fd_sc_hd__decap_12
XFILLER_28_205 VSUBS VSUBS _999_/VPB _999_/VPB sky130_fd_sc_hd__decap_4
XFILLER_51_274 VSUBS VSUBS _999_/VPB _999_/VPB sky130_fd_sc_hd__decap_12
XFILLER_51_241 VSUBS VSUBS _999_/VPB _999_/VPB sky130_fd_sc_hd__decap_8
XFILLER_7_109 VSUBS VSUBS _999_/VPB _999_/VPB sky130_fd_sc_hd__decap_8
XTAP_TAPCELL_ROW_21_133 VSUBS _999_/VPB sky130_fd_sc_hd__tapvpwrvgnd_1
XFILLER_22_12 VSUBS VSUBS _999_/VPB _999_/VPB sky130_fd_sc_hd__decap_12
X_930_ _933_/CLK _930_/D VSUBS VSUBS _999_/VPB _999_/VPB _930_/Q sky130_fd_sc_hd__dfxtp_1
XFILLER_22_67 VSUBS VSUBS _999_/VPB _999_/VPB sky130_fd_sc_hd__decap_12
XFILLER_59_352 VSUBS VSUBS _999_/VPB _999_/VPB sky130_fd_sc_hd__decap_8
X_792_ _792_/A _792_/B VSUBS VSUBS _999_/VPB _999_/VPB _797_/B sky130_fd_sc_hd__xnor2_1
X_861_ _873_/B _861_/B VSUBS VSUBS _999_/VPB _999_/VPB _864_/A sky130_fd_sc_hd__nand2_1
XFILLER_47_97 VSUBS VSUBS _999_/VPB _999_/VPB sky130_fd_sc_hd__decap_12
XFILLER_19_249 VSUBS VSUBS _999_/VPB _999_/VPB sky130_fd_sc_hd__fill_1
XFILLER_42_285 VSUBS VSUBS _999_/VPB _999_/VPB sky130_fd_sc_hd__fill_1
XFILLER_6_186 VSUBS VSUBS _999_/VPB _999_/VPB sky130_fd_sc_hd__decap_12
XFILLER_6_175 VSUBS VSUBS _999_/VPB _999_/VPB sky130_fd_sc_hd__decap_6
XFILLER_33_274 VSUBS VSUBS _999_/VPB _999_/VPB sky130_fd_sc_hd__decap_12
XFILLER_18_271 VSUBS VSUBS _999_/VPB _999_/VPB sky130_fd_sc_hd__fill_1
XFILLER_0_329 VSUBS VSUBS _999_/VPB _999_/VPB sky130_fd_sc_hd__fill_1
XFILLER_17_12 VSUBS VSUBS _999_/VPB _999_/VPB sky130_fd_sc_hd__decap_12
X_913_ _933_/CLK _913_/D VSUBS VSUBS _999_/VPB _999_/VPB _913_/Q sky130_fd_sc_hd__dfxtp_1
XFILLER_3_145 VSUBS VSUBS _999_/VPB _999_/VPB sky130_fd_sc_hd__decap_12
XFILLER_59_193 VSUBS VSUBS _999_/VPB _999_/VPB sky130_fd_sc_hd__fill_2
XTAP_TAPCELL_ROW_57_350 VSUBS _999_/VPB sky130_fd_sc_hd__tapvpwrvgnd_1
XFILLER_47_333 VSUBS VSUBS _999_/VPB _999_/VPB sky130_fd_sc_hd__fill_1
X_775_ _937_/Q _788_/A _765_/Y _774_/Y VSUBS VSUBS _999_/VPB _999_/VPB _776_/B sky130_fd_sc_hd__a22oi_1
X_844_ _966_/Q _833_/Y _587_/C VSUBS VSUBS _999_/VPB _999_/VPB _844_/Y sky130_fd_sc_hd__o21ai_0
XFILLER_30_211 VSUBS VSUBS _999_/VPB _999_/VPB sky130_fd_sc_hd__decap_12
XFILLER_15_241 VSUBS VSUBS _999_/VPB _999_/VPB sky130_fd_sc_hd__decap_12
XFILLER_15_263 VSUBS VSUBS _999_/VPB _999_/VPB sky130_fd_sc_hd__decap_12
XTAP_TAPCELL_ROW_40_250 VSUBS _999_/VPB sky130_fd_sc_hd__tapvpwrvgnd_1
XFILLER_53_325 VSUBS VSUBS _999_/VPB _999_/VPB sky130_fd_sc_hd__decap_12
XFILLER_17_0 VSUBS VSUBS _999_/VPB _999_/VPB sky130_fd_sc_hd__decap_12
XFILLER_21_277 VSUBS VSUBS _999_/VPB _999_/VPB sky130_fd_sc_hd__decap_3
XFILLER_0_115 VSUBS VSUBS _999_/VPB _999_/VPB sky130_fd_sc_hd__decap_4
X_560_ _983_/Q _979_/Q VSUBS VSUBS _999_/VPB _999_/VPB _765_/C sky130_fd_sc_hd__nor2_1
XFILLER_28_55 VSUBS VSUBS _999_/VPB _999_/VPB sky130_fd_sc_hd__decap_12
XTAP_TAPCELL_ROW_54_331 VSUBS _999_/VPB sky130_fd_sc_hd__tapvpwrvgnd_1
XFILLER_44_87 VSUBS VSUBS _999_/VPB _999_/VPB sky130_fd_sc_hd__decap_3
XFILLER_44_43 VSUBS VSUBS _999_/VPB _999_/VPB sky130_fd_sc_hd__decap_12
XFILLER_12_211 VSUBS VSUBS _999_/VPB _999_/VPB sky130_fd_sc_hd__decap_12
X_491_ _977_/Q _502_/C VSUBS VSUBS _999_/VPB _999_/VPB _491_/Y sky130_fd_sc_hd__nand2_1
XFILLER_60_31 VSUBS VSUBS _999_/VPB _999_/VPB sky130_fd_sc_hd__decap_12
XFILLER_12_255 VSUBS VSUBS _999_/VPB _999_/VPB sky130_fd_sc_hd__decap_12
XFILLER_5_48 VSUBS VSUBS _999_/VPB _999_/VPB sky130_fd_sc_hd__decap_12
X_758_ _759_/S _758_/B VSUBS VSUBS _999_/VPB _999_/VPB _758_/Y sky130_fd_sc_hd__nand2_1
X_689_ _927_/Q _926_/Q VSUBS VSUBS _999_/VPB _999_/VPB _701_/B sky130_fd_sc_hd__nor2_1
XFILLER_35_325 VSUBS VSUBS _999_/VPB _999_/VPB sky130_fd_sc_hd__decap_12
X_827_ ESPI_BIT_TICK _960_/Q _961_/Q VSUBS VSUBS _999_/VPB _999_/VPB _828_/C sky130_fd_sc_hd__a21oi_1
XTAP_TAPCELL_ROW_60_367 VSUBS _999_/VPB sky130_fd_sc_hd__tapvpwrvgnd_1
XFILLER_50_328 VSUBS VSUBS _999_/VPB _999_/VPB sky130_fd_sc_hd__fill_2
XFILLER_38_163 VSUBS VSUBS _999_/VPB _999_/VPB sky130_fd_sc_hd__decap_12
XFILLER_53_188 VSUBS VSUBS _999_/VPB _999_/VPB sky130_fd_sc_hd__decap_12
XFILLER_53_133 VSUBS VSUBS _999_/VPB _999_/VPB sky130_fd_sc_hd__decap_12
XTAP_TAPCELL_ROW_51_312 VSUBS _999_/VPB sky130_fd_sc_hd__tapvpwrvgnd_1
XFILLER_14_24 VSUBS VSUBS _999_/VPB _999_/VPB sky130_fd_sc_hd__decap_6
XFILLER_26_358 VSUBS VSUBS _999_/VPB _999_/VPB sky130_fd_sc_hd__decap_8
XFILLER_30_12 VSUBS VSUBS _999_/VPB _999_/VPB sky130_fd_sc_hd__decap_12
XTAP_TAPCELL_ROW_1_16 VSUBS _999_/VPB sky130_fd_sc_hd__tapvpwrvgnd_1
XFILLER_14_79 VSUBS VSUBS _999_/VPB _999_/VPB sky130_fd_sc_hd__decap_8
XFILLER_30_67 VSUBS VSUBS _999_/VPB _999_/VPB sky130_fd_sc_hd__decap_12
XFILLER_44_133 VSUBS VSUBS _999_/VPB _999_/VPB sky130_fd_sc_hd__fill_1
X_612_ _894_/Q _893_/Q VSUBS VSUBS _999_/VPB _999_/VPB _622_/B sky130_fd_sc_hd__nor2_1
X_543_ CH_ENABLE[0] _540_/B _542_/Y VSUBS VSUBS _999_/VPB _999_/VPB _543_/Y sky130_fd_sc_hd__a21oi_1
XFILLER_55_97 VSUBS VSUBS _999_/VPB _999_/VPB sky130_fd_sc_hd__decap_12
X_474_ _474_/A _474_/B VSUBS VSUBS _999_/VPB _999_/VPB _474_/Y sky130_fd_sc_hd__nand2_1
XFILLER_4_262 VSUBS VSUBS _999_/VPB _999_/VPB sky130_fd_sc_hd__fill_1
XFILLER_50_103 VSUBS VSUBS _999_/VPB _999_/VPB sky130_fd_sc_hd__decap_12
XFILLER_35_133 VSUBS VSUBS _999_/VPB _999_/VPB sky130_fd_sc_hd__decap_4
XFILLER_50_158 VSUBS VSUBS _999_/VPB _999_/VPB sky130_fd_sc_hd__decap_12
XFILLER_31_361 VSUBS VSUBS _999_/VPB _999_/VPB sky130_fd_sc_hd__decap_8
XFILLER_6_91 VSUBS VSUBS _999_/VPB _999_/VPB sky130_fd_sc_hd__decap_12
XFILLER_58_258 VSUBS VSUBS _999_/VPB _999_/VPB sky130_fd_sc_hd__decap_12
XFILLER_25_12 VSUBS VSUBS _999_/VPB _999_/VPB sky130_fd_sc_hd__decap_12
XFILLER_41_169 VSUBS VSUBS _999_/VPB _999_/VPB sky130_fd_sc_hd__decap_4
XFILLER_26_199 VSUBS VSUBS _999_/VPB _999_/VPB sky130_fd_sc_hd__decap_8
XFILLER_1_265 VSUBS VSUBS _999_/VPB _999_/VPB sky130_fd_sc_hd__fill_1
XFILLER_1_287 VSUBS VSUBS _999_/VPB _999_/VPB sky130_fd_sc_hd__decap_12
X_526_ _952_/Q _951_/Q _526_/C VSUBS VSUBS _999_/VPB _999_/VPB _526_/Y sky130_fd_sc_hd__nor3_1
XFILLER_32_147 VSUBS VSUBS _999_/VPB _999_/VPB sky130_fd_sc_hd__decap_3
XFILLER_32_103 VSUBS VSUBS _999_/VPB _999_/VPB sky130_fd_sc_hd__decap_12
XFILLER_17_133 VSUBS VSUBS _999_/VPB _999_/VPB sky130_fd_sc_hd__decap_3
XTAP_TAPCELL_ROW_27_172 VSUBS _999_/VPB sky130_fd_sc_hd__tapvpwrvgnd_1
XFILLER_9_321 VSUBS VSUBS _999_/VPB _999_/VPB sky130_fd_sc_hd__decap_12
XFILLER_13_361 VSUBS VSUBS _999_/VPB _999_/VPB sky130_fd_sc_hd__decap_8
X_457_ ESPI_CS_N _723_/A VSUBS VSUBS _999_/VPB _999_/VPB _828_/A sky130_fd_sc_hd__lpflow_inputiso1p_1
XFILLER_55_239 VSUBS VSUBS _999_/VPB _999_/VPB sky130_fd_sc_hd__fill_1
XFILLER_55_217 VSUBS VSUBS _999_/VPB _999_/VPB sky130_fd_sc_hd__decap_12
XFILLER_11_36 VSUBS VSUBS _999_/VPB _999_/VPB sky130_fd_sc_hd__decap_12
XFILLER_61_209 VSUBS VSUBS _999_/VPB _999_/VPB sky130_fd_sc_hd__fill_1
XFILLER_54_283 VSUBS VSUBS _999_/VPB _999_/VPB sky130_fd_sc_hd__decap_4
XFILLER_36_55 VSUBS VSUBS _999_/VPB _999_/VPB sky130_fd_sc_hd__decap_12
XTAP_TAPCELL_ROW_7_48 VSUBS _999_/VPB sky130_fd_sc_hd__tapvpwrvgnd_1
XFILLER_14_103 VSUBS VSUBS _999_/VPB _999_/VPB sky130_fd_sc_hd__decap_12
XFILLER_52_87 VSUBS VSUBS _999_/VPB _999_/VPB sky130_fd_sc_hd__decap_3
XFILLER_52_43 VSUBS VSUBS _999_/VPB _999_/VPB sky130_fd_sc_hd__decap_12
XFILLER_6_313 VSUBS VSUBS _999_/VPB _999_/VPB sky130_fd_sc_hd__decap_12
XFILLER_10_331 VSUBS VSUBS _999_/VPB _999_/VPB sky130_fd_sc_hd__decap_12
XFILLER_10_364 VSUBS VSUBS _999_/VPB _999_/VPB sky130_fd_sc_hd__decap_4
XTAP_TAPCELL_ROW_24_153 VSUBS _999_/VPB sky130_fd_sc_hd__tapvpwrvgnd_1
XFILLER_6_368 VSUBS VSUBS _999_/VPB _999_/VPB sky130_fd_sc_hd__fill_1
XTAP_TAPCELL_ROW_47_289 VSUBS _999_/VPB sky130_fd_sc_hd__tapvpwrvgnd_1
XFILLER_45_294 VSUBS VSUBS _999_/VPB _999_/VPB sky130_fd_sc_hd__decap_6
X_509_ _980_/Q _523_/B VSUBS VSUBS _999_/VPB _999_/VPB _509_/Y sky130_fd_sc_hd__nand2_1
XTAP_TAPCELL_ROW_30_189 VSUBS _999_/VPB sky130_fd_sc_hd__tapvpwrvgnd_1
XFILLER_47_0 VSUBS VSUBS _999_/VPB _999_/VPB sky130_fd_sc_hd__decap_12
XTAP_TAPCELL_ROW_38_234 VSUBS _999_/VPB sky130_fd_sc_hd__tapvpwrvgnd_1
XFILLER_36_283 VSUBS VSUBS _999_/VPB _999_/VPB sky130_fd_sc_hd__decap_12
XFILLER_51_286 VSUBS VSUBS _999_/VPB _999_/VPB sky130_fd_sc_hd__decap_8
XFILLER_11_117 VSUBS VSUBS _999_/VPB _999_/VPB sky130_fd_sc_hd__decap_3
XTAP_TAPCELL_ROW_21_134 VSUBS _999_/VPB sky130_fd_sc_hd__tapvpwrvgnd_1
XFILLER_22_24 VSUBS VSUBS _999_/VPB _999_/VPB sky130_fd_sc_hd__decap_6
XFILLER_22_79 VSUBS VSUBS _999_/VPB _999_/VPB sky130_fd_sc_hd__decap_8
X_791_ _943_/Q _791_/B VSUBS VSUBS _999_/VPB _999_/VPB _792_/B sky130_fd_sc_hd__xor2_1
X_860_ _971_/Q _859_/B _863_/B VSUBS VSUBS _999_/VPB _999_/VPB _862_/A sky130_fd_sc_hd__a21oi_1
XFILLER_42_264 VSUBS VSUBS _999_/VPB _999_/VPB sky130_fd_sc_hd__fill_2
XFILLER_6_198 VSUBS VSUBS _999_/VPB _999_/VPB sky130_fd_sc_hd__decap_12
X_989_ VSUBS VSUBS _999_/VPB _999_/VPB _989_/HI STATUS_REG[5] sky130_fd_sc_hd__conb_1
XFILLER_33_286 VSUBS VSUBS _999_/VPB _999_/VPB sky130_fd_sc_hd__fill_1
XFILLER_33_12 VSUBS VSUBS _999_/VPB _999_/VPB sky130_fd_sc_hd__decap_12
XFILLER_17_24 VSUBS VSUBS _999_/VPB _999_/VPB sky130_fd_sc_hd__decap_12
X_912_ _959_/CLK _912_/D VSUBS VSUBS _999_/VPB _999_/VPB _912_/Q sky130_fd_sc_hd__dfxtp_1
XFILLER_58_31 VSUBS VSUBS _999_/VPB _999_/VPB sky130_fd_sc_hd__decap_12
XFILLER_3_157 VSUBS VSUBS _999_/VPB _999_/VPB sky130_fd_sc_hd__decap_12
X_843_ _884_/Q _965_/Q _861_/B VSUBS VSUBS _999_/VPB _999_/VPB _843_/Y sky130_fd_sc_hd__mux2i_1
XTAP_TAPCELL_ROW_57_351 VSUBS _999_/VPB sky130_fd_sc_hd__tapvpwrvgnd_1
XFILLER_47_301 VSUBS VSUBS _999_/VPB _999_/VPB sky130_fd_sc_hd__decap_12
X_774_ _774_/A _777_/B VSUBS VSUBS _999_/VPB _999_/VPB _774_/Y sky130_fd_sc_hd__xnor2_1
XTAP_TAPCELL_ROW_40_251 VSUBS _999_/VPB sky130_fd_sc_hd__tapvpwrvgnd_1
XFILLER_30_223 VSUBS VSUBS _999_/VPB _999_/VPB sky130_fd_sc_hd__decap_8
XFILLER_15_253 VSUBS VSUBS _999_/VPB _999_/VPB sky130_fd_sc_hd__fill_1
XFILLER_15_275 VSUBS VSUBS _999_/VPB _999_/VPB sky130_fd_sc_hd__decap_8
XFILLER_57_109 VSUBS VSUBS _999_/VPB _999_/VPB sky130_fd_sc_hd__decap_8
XFILLER_53_337 VSUBS VSUBS _999_/VPB _999_/VPB sky130_fd_sc_hd__decap_12
XFILLER_38_356 VSUBS VSUBS _999_/VPB _999_/VPB sky130_fd_sc_hd__decap_12
XFILLER_0_149 VSUBS VSUBS _999_/VPB _999_/VPB sky130_fd_sc_hd__fill_1
XFILLER_28_12 VSUBS VSUBS _999_/VPB _999_/VPB sky130_fd_sc_hd__decap_12
XFILLER_28_67 VSUBS VSUBS _999_/VPB _999_/VPB sky130_fd_sc_hd__decap_12
XTAP_TAPCELL_ROW_54_332 VSUBS _999_/VPB sky130_fd_sc_hd__tapvpwrvgnd_1
XFILLER_44_55 VSUBS VSUBS _999_/VPB _999_/VPB sky130_fd_sc_hd__decap_12
XFILLER_12_223 VSUBS VSUBS _999_/VPB _999_/VPB sky130_fd_sc_hd__fill_1
XFILLER_12_267 VSUBS VSUBS _999_/VPB _999_/VPB sky130_fd_sc_hd__decap_3
X_490_ _892_/Q _891_/Q _828_/A VSUBS VSUBS _999_/VPB _999_/VPB _502_/C sky130_fd_sc_hd__nor3_1
XFILLER_60_87 VSUBS VSUBS _999_/VPB _999_/VPB sky130_fd_sc_hd__decap_3
XFILLER_60_43 VSUBS VSUBS _999_/VPB _999_/VPB sky130_fd_sc_hd__decap_12
XFILLER_8_238 VSUBS VSUBS _999_/VPB _999_/VPB sky130_fd_sc_hd__decap_12
XFILLER_39_109 VSUBS VSUBS _999_/VPB _999_/VPB sky130_fd_sc_hd__decap_8
X_826_ ESPI_BIT_TICK _960_/Q _825_/Y VSUBS VSUBS _999_/VPB _999_/VPB _960_/D sky130_fd_sc_hd__a21oi_1
X_757_ _759_/S _755_/Y _756_/Y VSUBS VSUBS _999_/VPB _999_/VPB _933_/D sky130_fd_sc_hd__a21oi_1
XFILLER_35_337 VSUBS VSUBS _999_/VPB _999_/VPB sky130_fd_sc_hd__decap_12
X_688_ _723_/A _688_/B _688_/C VSUBS VSUBS _999_/VPB _999_/VPB _916_/D sky130_fd_sc_hd__nor3_1
XTAP_TAPCELL_ROW_60_368 VSUBS _999_/VPB sky130_fd_sc_hd__tapvpwrvgnd_1
XFILLER_38_175 VSUBS VSUBS _999_/VPB _999_/VPB sky130_fd_sc_hd__decap_12
XFILLER_53_145 VSUBS VSUBS _999_/VPB _999_/VPB sky130_fd_sc_hd__decap_3
XTAP_TAPCELL_ROW_51_313 VSUBS _999_/VPB sky130_fd_sc_hd__tapvpwrvgnd_1
XFILLER_30_79 VSUBS VSUBS _999_/VPB _999_/VPB sky130_fd_sc_hd__decap_8
XFILLER_30_24 VSUBS VSUBS _999_/VPB _999_/VPB sky130_fd_sc_hd__decap_6
XTAP_TAPCELL_ROW_1_17 VSUBS _999_/VPB sky130_fd_sc_hd__tapvpwrvgnd_1
X_473_ LAST_CMD[7] LAST_CMD[6] LAST_CMD[5] LAST_CMD[4] VSUBS VSUBS _999_/VPB _999_/VPB
+ _474_/B sky130_fd_sc_hd__nor4_1
X_611_ _609_/Y _610_/X _828_/A VSUBS VSUBS _999_/VPB _999_/VPB _892_/D sky130_fd_sc_hd__a21oi_1
X_542_ _899_/Q _898_/Q _897_/Q _896_/Q VSUBS VSUBS _999_/VPB _999_/VPB _542_/Y sky130_fd_sc_hd__nor4b_1
XFILLER_29_153 VSUBS VSUBS _999_/VPB _999_/VPB sky130_fd_sc_hd__decap_8
X_809_ _809_/A _809_/B VSUBS VSUBS _999_/VPB _999_/VPB _954_/D sky130_fd_sc_hd__nor2_1
XFILLER_50_115 VSUBS VSUBS _999_/VPB _999_/VPB sky130_fd_sc_hd__decap_12
XFILLER_14_307 VSUBS VSUBS _999_/VPB _999_/VPB sky130_fd_sc_hd__decap_12
XFILLER_25_24 VSUBS VSUBS _999_/VPB _999_/VPB sky130_fd_sc_hd__decap_12
XFILLER_26_156 VSUBS VSUBS _999_/VPB _999_/VPB sky130_fd_sc_hd__decap_12
XFILLER_41_12 VSUBS VSUBS _999_/VPB _999_/VPB sky130_fd_sc_hd__decap_12
XFILLER_1_299 VSUBS VSUBS _999_/VPB _999_/VPB sky130_fd_sc_hd__fill_1
X_525_ _951_/Q _526_/C VSUBS VSUBS _999_/VPB _999_/VPB _658_/A sky130_fd_sc_hd__nor2_1
XFILLER_32_115 VSUBS VSUBS _999_/VPB _999_/VPB sky130_fd_sc_hd__decap_12
X_456_ ESPI_CS_N _723_/A VSUBS VSUBS _999_/VPB _999_/VPB _873_/B sky130_fd_sc_hd__nor2_1
XTAP_TAPCELL_ROW_27_173 VSUBS _999_/VPB sky130_fd_sc_hd__tapvpwrvgnd_1
XFILLER_9_333 VSUBS VSUBS _999_/VPB _999_/VPB sky130_fd_sc_hd__decap_12
XFILLER_55_229 VSUBS VSUBS _999_/VPB _999_/VPB sky130_fd_sc_hd__fill_2
XFILLER_31_181 VSUBS VSUBS _999_/VPB _999_/VPB sky130_fd_sc_hd__decap_8
XFILLER_11_48 VSUBS VSUBS _999_/VPB _999_/VPB sky130_fd_sc_hd__decap_12
XFILLER_36_12 VSUBS VSUBS _999_/VPB _999_/VPB sky130_fd_sc_hd__decap_12
XFILLER_36_67 VSUBS VSUBS _999_/VPB _999_/VPB sky130_fd_sc_hd__decap_12
XTAP_TAPCELL_ROW_7_49 VSUBS _999_/VPB sky130_fd_sc_hd__tapvpwrvgnd_1
XFILLER_14_115 VSUBS VSUBS _999_/VPB _999_/VPB sky130_fd_sc_hd__decap_12
XFILLER_52_55 VSUBS VSUBS _999_/VPB _999_/VPB sky130_fd_sc_hd__decap_12
XFILLER_6_325 VSUBS VSUBS _999_/VPB _999_/VPB sky130_fd_sc_hd__decap_4
XFILLER_10_343 VSUBS VSUBS _999_/VPB _999_/VPB sky130_fd_sc_hd__fill_1
XFILLER_22_181 VSUBS VSUBS _999_/VPB _999_/VPB sky130_fd_sc_hd__decap_8
XTAP_TAPCELL_ROW_24_154 VSUBS _999_/VPB sky130_fd_sc_hd__tapvpwrvgnd_1
XFILLER_7_0 VSUBS VSUBS _999_/VPB _999_/VPB sky130_fd_sc_hd__decap_12
XFILLER_45_273 VSUBS VSUBS _999_/VPB _999_/VPB sky130_fd_sc_hd__fill_1
X_439_ _949_/Q VSUBS VSUBS _999_/VPB _999_/VPB _439_/Y sky130_fd_sc_hd__clkinv_1
X_508_ _541_/C _508_/B VSUBS VSUBS _999_/VPB _999_/VPB _540_/A sky130_fd_sc_hd__nor2_1
XFILLER_9_163 VSUBS VSUBS _999_/VPB _999_/VPB sky130_fd_sc_hd__fill_1
XTAP_TAPCELL_ROW_38_235 VSUBS _999_/VPB sky130_fd_sc_hd__tapvpwrvgnd_1
XFILLER_36_295 VSUBS VSUBS _999_/VPB _999_/VPB sky130_fd_sc_hd__decap_12
XTAP_TAPCELL_ROW_21_135 VSUBS _999_/VPB sky130_fd_sc_hd__tapvpwrvgnd_1
XFILLER_59_321 VSUBS VSUBS _999_/VPB _999_/VPB sky130_fd_sc_hd__fill_1
X_790_ _790_/A _790_/B VSUBS VSUBS _999_/VPB _999_/VPB _940_/D sky130_fd_sc_hd__nor2_1
XTAP_TAPCELL_ROW_12_80 VSUBS _999_/VPB sky130_fd_sc_hd__tapvpwrvgnd_1
XFILLER_27_251 VSUBS VSUBS _999_/VPB _999_/VPB sky130_fd_sc_hd__decap_12
XFILLER_42_232 VSUBS VSUBS _999_/VPB _999_/VPB sky130_fd_sc_hd__decap_12
XFILLER_10_151 VSUBS VSUBS _999_/VPB _999_/VPB sky130_fd_sc_hd__decap_12
XFILLER_12_91 VSUBS VSUBS _999_/VPB _999_/VPB sky130_fd_sc_hd__decap_12
X_988_ VSUBS VSUBS _999_/VPB _999_/VPB _988_/HI STATUS_REG[4] sky130_fd_sc_hd__conb_1
XTAP_TAPCELL_ROW_35_216 VSUBS _999_/VPB sky130_fd_sc_hd__tapvpwrvgnd_1
XFILLER_33_232 VSUBS VSUBS _999_/VPB _999_/VPB sky130_fd_sc_hd__fill_2
XFILLER_17_36 VSUBS VSUBS _999_/VPB _999_/VPB sky130_fd_sc_hd__decap_12
XFILLER_33_24 VSUBS VSUBS _999_/VPB _999_/VPB sky130_fd_sc_hd__decap_12
XFILLER_24_221 VSUBS VSUBS _999_/VPB _999_/VPB sky130_fd_sc_hd__fill_1
XFILLER_24_254 VSUBS VSUBS _999_/VPB _999_/VPB sky130_fd_sc_hd__decap_12
XFILLER_58_87 VSUBS VSUBS _999_/VPB _999_/VPB sky130_fd_sc_hd__decap_3
XFILLER_58_43 VSUBS VSUBS _999_/VPB _999_/VPB sky130_fd_sc_hd__decap_12
X_911_ _933_/CLK _911_/D VSUBS VSUBS _999_/VPB _999_/VPB _911_/Q sky130_fd_sc_hd__dfxtp_1
XFILLER_47_313 VSUBS VSUBS _999_/VPB _999_/VPB sky130_fd_sc_hd__decap_12
XFILLER_3_169 VSUBS VSUBS _999_/VPB _999_/VPB sky130_fd_sc_hd__decap_8
X_842_ _833_/Y _840_/Y _841_/Y VSUBS VSUBS _999_/VPB _999_/VPB _965_/D sky130_fd_sc_hd__a21oi_1
XTAP_TAPCELL_ROW_57_352 VSUBS _999_/VPB sky130_fd_sc_hd__tapvpwrvgnd_1
X_773_ _939_/Q _879_/Q VSUBS VSUBS _999_/VPB _999_/VPB _777_/B sky130_fd_sc_hd__xor2_1
XFILLER_15_221 VSUBS VSUBS _999_/VPB _999_/VPB sky130_fd_sc_hd__decap_12
XFILLER_30_279 VSUBS VSUBS _999_/VPB _999_/VPB sky130_fd_sc_hd__decap_12
XFILLER_30_268 VSUBS VSUBS _999_/VPB _999_/VPB sky130_fd_sc_hd__fill_2
XFILLER_38_368 VSUBS VSUBS _999_/VPB _999_/VPB sky130_fd_sc_hd__fill_1
XFILLER_53_349 VSUBS VSUBS _999_/VPB _999_/VPB sky130_fd_sc_hd__decap_8
XFILLER_0_61 VSUBS VSUBS _999_/VPB _999_/VPB sky130_fd_sc_hd__decap_12
XFILLER_56_165 VSUBS VSUBS _999_/VPB _999_/VPB sky130_fd_sc_hd__decap_12
XTAP_TAPCELL_ROW_54_333 VSUBS _999_/VPB sky130_fd_sc_hd__tapvpwrvgnd_1
XFILLER_44_305 VSUBS VSUBS _999_/VPB _999_/VPB sky130_fd_sc_hd__decap_12
XFILLER_44_12 VSUBS VSUBS _999_/VPB _999_/VPB sky130_fd_sc_hd__decap_12
XFILLER_28_24 VSUBS VSUBS _999_/VPB _999_/VPB sky130_fd_sc_hd__decap_6
XFILLER_28_79 VSUBS VSUBS _999_/VPB _999_/VPB sky130_fd_sc_hd__decap_8
XFILLER_60_55 VSUBS VSUBS _999_/VPB _999_/VPB sky130_fd_sc_hd__decap_12
XFILLER_44_67 VSUBS VSUBS _999_/VPB _999_/VPB sky130_fd_sc_hd__decap_12
X_756_ _933_/Q _759_/S _873_/B VSUBS VSUBS _999_/VPB _999_/VPB _756_/Y sky130_fd_sc_hd__o21ai_0
XFILLER_47_121 VSUBS VSUBS _999_/VPB _999_/VPB sky130_fd_sc_hd__decap_12
X_825_ ESPI_BIT_TICK _960_/Q _873_/B VSUBS VSUBS _999_/VPB _999_/VPB _825_/Y sky130_fd_sc_hd__o21ai_0
XFILLER_47_165 VSUBS VSUBS _999_/VPB _999_/VPB sky130_fd_sc_hd__fill_1
XFILLER_35_349 VSUBS VSUBS _999_/VPB _999_/VPB sky130_fd_sc_hd__fill_2
X_687_ _685_/A _703_/A CH_ENABLE[3] VSUBS VSUBS _999_/VPB _999_/VPB _688_/C sky130_fd_sc_hd__a21oi_1
XTAP_TAPCELL_ROW_60_369 VSUBS _999_/VPB sky130_fd_sc_hd__tapvpwrvgnd_1
XFILLER_22_0 VSUBS VSUBS _999_/VPB _999_/VPB sky130_fd_sc_hd__decap_12
XFILLER_38_187 VSUBS VSUBS _999_/VPB _999_/VPB sky130_fd_sc_hd__decap_12
XTAP_TAPCELL_ROW_51_314 VSUBS _999_/VPB sky130_fd_sc_hd__tapvpwrvgnd_1
XFILLER_39_12 VSUBS VSUBS _999_/VPB _999_/VPB sky130_fd_sc_hd__decap_12
XFILLER_29_121 VSUBS VSUBS _999_/VPB _999_/VPB sky130_fd_sc_hd__decap_8
X_610_ _977_/Q _606_/B VSUBS VSUBS _999_/VPB _999_/VPB _610_/X sky130_fd_sc_hd__lpflow_inputiso1p_1
X_472_ LAST_CMD[2] LAST_CMD[1] _471_/Y LAST_CMD[3] VSUBS VSUBS _999_/VPB _999_/VPB
+ _474_/A sky130_fd_sc_hd__o22ai_1
X_541_ LAST_CMD[0] _541_/B _541_/C VSUBS VSUBS _999_/VPB _999_/VPB _541_/X sky130_fd_sc_hd__or3_1
XFILLER_20_91 VSUBS VSUBS _999_/VPB _999_/VPB sky130_fd_sc_hd__decap_12
X_808_ _953_/Q _803_/Y _459_/B VSUBS VSUBS _999_/VPB _999_/VPB _809_/B sky130_fd_sc_hd__o21ai_0
X_739_ _930_/Q _759_/S _873_/B VSUBS VSUBS _999_/VPB _999_/VPB _739_/Y sky130_fd_sc_hd__o21ai_0
XFILLER_50_127 VSUBS VSUBS _999_/VPB _999_/VPB sky130_fd_sc_hd__decap_6
XFILLER_35_179 VSUBS VSUBS _999_/VPB _999_/VPB sky130_fd_sc_hd__fill_1
XFILLER_14_319 VSUBS VSUBS _999_/VPB _999_/VPB sky130_fd_sc_hd__decap_8
XFILLER_25_36 VSUBS VSUBS _999_/VPB _999_/VPB sky130_fd_sc_hd__decap_12
XFILLER_26_168 VSUBS VSUBS _999_/VPB _999_/VPB sky130_fd_sc_hd__decap_12
XFILLER_41_24 VSUBS VSUBS _999_/VPB _999_/VPB sky130_fd_sc_hd__decap_12
XFILLER_57_282 VSUBS VSUBS _999_/VPB _999_/VPB sky130_fd_sc_hd__fill_1
X_524_ _524_/A _659_/B VSUBS VSUBS _999_/VPB _999_/VPB _524_/Y sky130_fd_sc_hd__nor2_1
XFILLER_40_171 VSUBS VSUBS _999_/VPB _999_/VPB sky130_fd_sc_hd__fill_1
X_455_ _944_/Q ESPI_CS_N VSUBS VSUBS _999_/VPB _999_/VPB _523_/B sky130_fd_sc_hd__lpflow_isobufsrc_1
XFILLER_32_127 VSUBS VSUBS _999_/VPB _999_/VPB sky130_fd_sc_hd__decap_12
XFILLER_9_301 VSUBS VSUBS _999_/VPB _999_/VPB sky130_fd_sc_hd__decap_8
XFILLER_9_345 VSUBS VSUBS _999_/VPB _999_/VPB sky130_fd_sc_hd__decap_12
XFILLER_48_271 VSUBS VSUBS _999_/VPB _999_/VPB sky130_fd_sc_hd__decap_12
XFILLER_23_105 VSUBS VSUBS _999_/VPB _999_/VPB sky130_fd_sc_hd__fill_1
XFILLER_36_24 VSUBS VSUBS _999_/VPB _999_/VPB sky130_fd_sc_hd__decap_6
XFILLER_52_12 VSUBS VSUBS _999_/VPB _999_/VPB sky130_fd_sc_hd__decap_12
XFILLER_36_79 VSUBS VSUBS _999_/VPB _999_/VPB sky130_fd_sc_hd__decap_8
XFILLER_10_300 VSUBS VSUBS _999_/VPB _999_/VPB sky130_fd_sc_hd__decap_12
XFILLER_14_127 VSUBS VSUBS _999_/VPB _999_/VPB sky130_fd_sc_hd__fill_2
XFILLER_14_149 VSUBS VSUBS _999_/VPB _999_/VPB sky130_fd_sc_hd__fill_1
XTAP_TAPCELL_ROW_24_155 VSUBS _999_/VPB sky130_fd_sc_hd__tapvpwrvgnd_1
XFILLER_52_67 VSUBS VSUBS _999_/VPB _999_/VPB sky130_fd_sc_hd__decap_12
XFILLER_60_211 VSUBS VSUBS _999_/VPB _999_/VPB sky130_fd_sc_hd__decap_12
XFILLER_45_241 VSUBS VSUBS _999_/VPB _999_/VPB sky130_fd_sc_hd__decap_12
XTAP_TAPCELL_ROW_15_100 VSUBS _999_/VPB sky130_fd_sc_hd__tapvpwrvgnd_1
X_438_ _924_/Q VSUBS VSUBS _999_/VPB _999_/VPB _438_/Y sky130_fd_sc_hd__clkinv_1
X_507_ LAST_CMD[3] LAST_CMD[2] LAST_CMD[1] LAST_CMD[0] VSUBS VSUBS _999_/VPB _999_/VPB
+ _508_/B sky130_fd_sc_hd__or4_1
XTAP_TAPCELL_ROW_38_236 VSUBS _999_/VPB sky130_fd_sc_hd__tapvpwrvgnd_1
XFILLER_3_61 VSUBS VSUBS _999_/VPB _999_/VPB sky130_fd_sc_hd__decap_12
XFILLER_51_211 VSUBS VSUBS _999_/VPB _999_/VPB sky130_fd_sc_hd__fill_1
XFILLER_3_307 VSUBS VSUBS _999_/VPB _999_/VPB sky130_fd_sc_hd__fill_1
XTAP_TAPCELL_ROW_21_136 VSUBS _999_/VPB sky130_fd_sc_hd__tapvpwrvgnd_1
XFILLER_47_12 VSUBS VSUBS _999_/VPB _999_/VPB sky130_fd_sc_hd__decap_12
XTAP_TAPCELL_ROW_12_81 VSUBS _999_/VPB sky130_fd_sc_hd__tapvpwrvgnd_1
XFILLER_42_211 VSUBS VSUBS _999_/VPB _999_/VPB sky130_fd_sc_hd__decap_8
XFILLER_19_208 VSUBS VSUBS _999_/VPB _999_/VPB sky130_fd_sc_hd__fill_2
XFILLER_27_241 VSUBS VSUBS _999_/VPB _999_/VPB sky130_fd_sc_hd__decap_4
XFILLER_27_263 VSUBS VSUBS _999_/VPB _999_/VPB sky130_fd_sc_hd__fill_2
XFILLER_42_244 VSUBS VSUBS _999_/VPB _999_/VPB sky130_fd_sc_hd__decap_12
XFILLER_10_163 VSUBS VSUBS _999_/VPB _999_/VPB sky130_fd_sc_hd__decap_6
X_987_ VSUBS VSUBS _999_/VPB _999_/VPB STATUS_REG[3] _987_/LO sky130_fd_sc_hd__conb_1
XTAP_TAPCELL_ROW_35_217 VSUBS _999_/VPB sky130_fd_sc_hd__tapvpwrvgnd_1
XFILLER_33_222 VSUBS VSUBS _999_/VPB _999_/VPB sky130_fd_sc_hd__decap_6
XFILLER_18_241 VSUBS VSUBS _999_/VPB _999_/VPB sky130_fd_sc_hd__decap_12
XFILLER_18_296 VSUBS VSUBS _999_/VPB _999_/VPB sky130_fd_sc_hd__fill_1
XFILLER_52_0 VSUBS VSUBS _999_/VPB _999_/VPB sky130_fd_sc_hd__decap_12
XFILLER_17_48 VSUBS VSUBS _999_/VPB _999_/VPB sky130_fd_sc_hd__decap_12
XFILLER_24_211 VSUBS VSUBS _999_/VPB _999_/VPB sky130_fd_sc_hd__decap_3
XFILLER_33_36 VSUBS VSUBS _999_/VPB _999_/VPB sky130_fd_sc_hd__decap_12
XFILLER_24_266 VSUBS VSUBS _999_/VPB _999_/VPB sky130_fd_sc_hd__decap_4
XFILLER_24_288 VSUBS VSUBS _999_/VPB _999_/VPB sky130_fd_sc_hd__decap_12
X_910_ _933_/CLK _910_/D VSUBS VSUBS _999_/VPB _999_/VPB _910_/Q sky130_fd_sc_hd__dfxtp_1
XFILLER_58_55 VSUBS VSUBS _999_/VPB _999_/VPB sky130_fd_sc_hd__decap_12
XFILLER_47_325 VSUBS VSUBS _999_/VPB _999_/VPB sky130_fd_sc_hd__decap_8
X_772_ _828_/A _772_/B VSUBS VSUBS _999_/VPB _999_/VPB _936_/D sky130_fd_sc_hd__nor2_1
X_841_ _965_/Q _833_/Y _587_/C VSUBS VSUBS _999_/VPB _999_/VPB _841_/Y sky130_fd_sc_hd__o21ai_0
XTAP_TAPCELL_ROW_57_353 VSUBS _999_/VPB sky130_fd_sc_hd__tapvpwrvgnd_1
XFILLER_47_358 VSUBS VSUBS _999_/VPB _999_/VPB sky130_fd_sc_hd__fill_2
XFILLER_15_233 VSUBS VSUBS _999_/VPB _999_/VPB sky130_fd_sc_hd__decap_6
XFILLER_30_236 VSUBS VSUBS _999_/VPB _999_/VPB sky130_fd_sc_hd__decap_12
XFILLER_15_299 VSUBS VSUBS _999_/VPB _999_/VPB sky130_fd_sc_hd__fill_1
XFILLER_61_361 VSUBS VSUBS _999_/VPB _999_/VPB sky130_fd_sc_hd__decap_8
XFILLER_0_73 VSUBS VSUBS _999_/VPB _999_/VPB sky130_fd_sc_hd__decap_12
XFILLER_21_225 VSUBS VSUBS _999_/VPB _999_/VPB sky130_fd_sc_hd__fill_1
XFILLER_56_177 VSUBS VSUBS _999_/VPB _999_/VPB sky130_fd_sc_hd__decap_8
XTAP_TAPCELL_ROW_54_334 VSUBS _999_/VPB sky130_fd_sc_hd__tapvpwrvgnd_1
XFILLER_44_317 VSUBS VSUBS _999_/VPB _999_/VPB sky130_fd_sc_hd__decap_12
XFILLER_44_24 VSUBS VSUBS _999_/VPB _999_/VPB sky130_fd_sc_hd__decap_6
XFILLER_60_67 VSUBS VSUBS _999_/VPB _999_/VPB sky130_fd_sc_hd__decap_12
XFILLER_60_12 VSUBS VSUBS _999_/VPB _999_/VPB sky130_fd_sc_hd__decap_12
XFILLER_44_79 VSUBS VSUBS _999_/VPB _999_/VPB sky130_fd_sc_hd__decap_8
XFILLER_12_247 VSUBS VSUBS _999_/VPB _999_/VPB sky130_fd_sc_hd__fill_1
X_824_ _824_/A _824_/B VSUBS VSUBS _999_/VPB _999_/VPB _959_/D sky130_fd_sc_hd__nor2_1
X_755_ _755_/A _758_/B VSUBS VSUBS _999_/VPB _999_/VPB _755_/Y sky130_fd_sc_hd__xnor2_1
XFILLER_47_133 VSUBS VSUBS _999_/VPB _999_/VPB sky130_fd_sc_hd__decap_12
XFILLER_43_361 VSUBS VSUBS _999_/VPB _999_/VPB sky130_fd_sc_hd__decap_8
XFILLER_18_91 VSUBS VSUBS _999_/VPB _999_/VPB sky130_fd_sc_hd__decap_12
X_686_ _945_/Q _978_/Q _685_/Y VSUBS VSUBS _999_/VPB _999_/VPB _688_/B sky130_fd_sc_hd__a21oi_1
Xclkbuf_3_5__f_clk clkbuf_0_clk/X VSUBS VSUBS _999_/VPB _999_/VPB _933_/CLK sky130_fd_sc_hd__clkbuf_16
XFILLER_41_309 VSUBS VSUBS _999_/VPB _999_/VPB sky130_fd_sc_hd__fill_1
XFILLER_38_199 VSUBS VSUBS _999_/VPB _999_/VPB sky130_fd_sc_hd__decap_8
XFILLER_38_155 VSUBS VSUBS _999_/VPB _999_/VPB sky130_fd_sc_hd__decap_3
XFILLER_15_0 VSUBS VSUBS _999_/VPB _999_/VPB sky130_fd_sc_hd__decap_12
XFILLER_26_328 VSUBS VSUBS _999_/VPB _999_/VPB sky130_fd_sc_hd__fill_2
XTAP_TAPCELL_ROW_51_315 VSUBS _999_/VPB sky130_fd_sc_hd__tapvpwrvgnd_1
XFILLER_39_24 VSUBS VSUBS _999_/VPB _999_/VPB sky130_fd_sc_hd__decap_12
XFILLER_55_12 VSUBS VSUBS _999_/VPB _999_/VPB sky130_fd_sc_hd__decap_12
XFILLER_44_103 VSUBS VSUBS _999_/VPB _999_/VPB sky130_fd_sc_hd__decap_12
X_540_ _540_/A _540_/B VSUBS VSUBS _999_/VPB _999_/VPB _540_/Y sky130_fd_sc_hd__nand2_1
XFILLER_40_331 VSUBS VSUBS _999_/VPB _999_/VPB sky130_fd_sc_hd__decap_12
X_471_ LAST_CMD[2] LAST_CMD[1] LAST_CMD[0] VSUBS VSUBS _999_/VPB _999_/VPB _471_/Y
+ sky130_fd_sc_hd__a21boi_0
XFILLER_25_361 VSUBS VSUBS _999_/VPB _999_/VPB sky130_fd_sc_hd__decap_8
X_807_ _954_/Q _822_/B VSUBS VSUBS _999_/VPB _999_/VPB _809_/A sky130_fd_sc_hd__nor2_1
X_738_ _738_/A _742_/A VSUBS VSUBS _999_/VPB _999_/VPB _738_/Y sky130_fd_sc_hd__xnor2_1
X_669_ _948_/Q _662_/Y _459_/B VSUBS VSUBS _999_/VPB _999_/VPB _669_/Y sky130_fd_sc_hd__o21ai_0
XFILLER_35_147 VSUBS VSUBS _999_/VPB _999_/VPB sky130_fd_sc_hd__decap_12
XFILLER_26_103 VSUBS VSUBS _999_/VPB _999_/VPB sky130_fd_sc_hd__decap_12
XFILLER_41_117 VSUBS VSUBS _999_/VPB _999_/VPB sky130_fd_sc_hd__decap_3
XFILLER_22_331 VSUBS VSUBS _999_/VPB _999_/VPB sky130_fd_sc_hd__decap_12
XFILLER_25_48 VSUBS VSUBS _999_/VPB _999_/VPB sky130_fd_sc_hd__decap_12
XFILLER_26_147 VSUBS VSUBS _999_/VPB _999_/VPB sky130_fd_sc_hd__decap_3
XFILLER_41_36 VSUBS VSUBS _999_/VPB _999_/VPB sky130_fd_sc_hd__decap_12
XFILLER_49_239 VSUBS VSUBS _999_/VPB _999_/VPB sky130_fd_sc_hd__fill_1
X_523_ _976_/Q _523_/B VSUBS VSUBS _999_/VPB _999_/VPB _526_/C sky130_fd_sc_hd__nand2_1
XFILLER_32_139 VSUBS VSUBS _999_/VPB _999_/VPB sky130_fd_sc_hd__decap_8
X_454_ ESPI_RESET_N rst_n VSUBS VSUBS _999_/VPB _999_/VPB _723_/A sky130_fd_sc_hd__nand2_1
XFILLER_9_357 VSUBS VSUBS _999_/VPB _999_/VPB sky130_fd_sc_hd__decap_3
XFILLER_48_283 VSUBS VSUBS _999_/VPB _999_/VPB sky130_fd_sc_hd__decap_12
XFILLER_23_117 VSUBS VSUBS _999_/VPB _999_/VPB sky130_fd_sc_hd__decap_3
XFILLER_31_194 VSUBS VSUBS _999_/VPB _999_/VPB sky130_fd_sc_hd__decap_3
XFILLER_39_261 VSUBS VSUBS _999_/VPB _999_/VPB sky130_fd_sc_hd__decap_3
XFILLER_52_79 VSUBS VSUBS _999_/VPB _999_/VPB sky130_fd_sc_hd__decap_8
XFILLER_52_24 VSUBS VSUBS _999_/VPB _999_/VPB sky130_fd_sc_hd__decap_6
XFILLER_10_312 VSUBS VSUBS _999_/VPB _999_/VPB sky130_fd_sc_hd__fill_2
XFILLER_60_223 VSUBS VSUBS _999_/VPB _999_/VPB sky130_fd_sc_hd__decap_12
XFILLER_45_253 VSUBS VSUBS _999_/VPB _999_/VPB sky130_fd_sc_hd__decap_12
X_506_ LAST_CMD[3] LAST_CMD[2] LAST_CMD[1] _541_/C VSUBS VSUBS _999_/VPB _999_/VPB
+ _682_/B sky130_fd_sc_hd__nor4_1
XTAP_TAPCELL_ROW_15_101 VSUBS _999_/VPB sky130_fd_sc_hd__tapvpwrvgnd_1
XFILLER_26_91 VSUBS VSUBS _999_/VPB _999_/VPB sky130_fd_sc_hd__decap_12
XFILLER_60_267 VSUBS VSUBS _999_/VPB _999_/VPB sky130_fd_sc_hd__decap_3
X_437_ _926_/Q VSUBS VSUBS _999_/VPB _999_/VPB _437_/Y sky130_fd_sc_hd__clkinv_1
XFILLER_9_121 VSUBS VSUBS _999_/VPB _999_/VPB sky130_fd_sc_hd__decap_12
XTAP_TAPCELL_ROW_38_237 VSUBS _999_/VPB sky130_fd_sc_hd__tapvpwrvgnd_1
XFILLER_3_73 VSUBS VSUBS _999_/VPB _999_/VPB sky130_fd_sc_hd__decap_12
XFILLER_28_209 VSUBS VSUBS _999_/VPB _999_/VPB sky130_fd_sc_hd__fill_1
XFILLER_11_109 VSUBS VSUBS _999_/VPB _999_/VPB sky130_fd_sc_hd__decap_8
XTAP_TAPCELL_ROW_21_137 VSUBS _999_/VPB sky130_fd_sc_hd__tapvpwrvgnd_1
XFILLER_59_301 VSUBS VSUBS _999_/VPB _999_/VPB sky130_fd_sc_hd__decap_12
XFILLER_47_24 VSUBS VSUBS _999_/VPB _999_/VPB sky130_fd_sc_hd__decap_12
XTAP_TAPCELL_ROW_12_82 VSUBS _999_/VPB sky130_fd_sc_hd__tapvpwrvgnd_1
XFILLER_42_256 VSUBS VSUBS _999_/VPB _999_/VPB sky130_fd_sc_hd__decap_8
X_986_ VSUBS VSUBS _999_/VPB _999_/VPB STATUS_REG[2] _986_/LO sky130_fd_sc_hd__conb_1
XTAP_TAPCELL_ROW_35_218 VSUBS _999_/VPB sky130_fd_sc_hd__tapvpwrvgnd_1
XFILLER_18_253 VSUBS VSUBS _999_/VPB _999_/VPB sky130_fd_sc_hd__decap_12
XFILLER_45_0 VSUBS VSUBS _999_/VPB _999_/VPB sky130_fd_sc_hd__decap_12
XFILLER_33_48 VSUBS VSUBS _999_/VPB _999_/VPB sky130_fd_sc_hd__decap_12
XFILLER_58_12 VSUBS VSUBS _999_/VPB _999_/VPB sky130_fd_sc_hd__decap_12
XFILLER_3_105 VSUBS VSUBS _999_/VPB _999_/VPB sky130_fd_sc_hd__fill_1
XFILLER_58_67 VSUBS VSUBS _999_/VPB _999_/VPB sky130_fd_sc_hd__decap_12
X_771_ _936_/Q _788_/A _765_/Y _770_/Y VSUBS VSUBS _999_/VPB _999_/VPB _772_/B sky130_fd_sc_hd__a22oi_1
X_840_ _883_/Q _964_/Q _861_/B VSUBS VSUBS _999_/VPB _999_/VPB _840_/Y sky130_fd_sc_hd__mux2i_1
XFILLER_30_248 VSUBS VSUBS _999_/VPB _999_/VPB sky130_fd_sc_hd__decap_12
X_969_ _969_/CLK _969_/D VSUBS VSUBS _999_/VPB _999_/VPB _969_/Q sky130_fd_sc_hd__dfxtp_1
XFILLER_0_85 VSUBS VSUBS _999_/VPB _999_/VPB sky130_fd_sc_hd__decap_4
XFILLER_9_61 VSUBS VSUBS _999_/VPB _999_/VPB sky130_fd_sc_hd__decap_12
XFILLER_56_145 VSUBS VSUBS _999_/VPB _999_/VPB sky130_fd_sc_hd__fill_1
XFILLER_0_119 VSUBS VSUBS _999_/VPB _999_/VPB sky130_fd_sc_hd__fill_1
XTAP_TAPCELL_ROW_54_335 VSUBS _999_/VPB sky130_fd_sc_hd__tapvpwrvgnd_1
XFILLER_44_329 VSUBS VSUBS _999_/VPB _999_/VPB sky130_fd_sc_hd__fill_1
XFILLER_60_79 VSUBS VSUBS _999_/VPB _999_/VPB sky130_fd_sc_hd__decap_8
XFILLER_60_24 VSUBS VSUBS _999_/VPB _999_/VPB sky130_fd_sc_hd__decap_6
X_823_ _958_/Q _803_/Y _459_/B VSUBS VSUBS _999_/VPB _999_/VPB _824_/B sky130_fd_sc_hd__o21ai_0
X_754_ _754_/A _754_/B VSUBS VSUBS _999_/VPB _999_/VPB _758_/B sky130_fd_sc_hd__xnor2_1
XFILLER_47_145 VSUBS VSUBS _999_/VPB _999_/VPB sky130_fd_sc_hd__decap_12
X_685_ _685_/A _703_/A VSUBS VSUBS _999_/VPB _999_/VPB _685_/Y sky130_fd_sc_hd__nand2_1
XFILLER_34_91 VSUBS VSUBS _999_/VPB _999_/VPB sky130_fd_sc_hd__decap_12
XTAP_TAPCELL_ROW_5_40 VSUBS _999_/VPB sky130_fd_sc_hd__tapvpwrvgnd_1
XFILLER_7_241 VSUBS VSUBS _999_/VPB _999_/VPB sky130_fd_sc_hd__decap_12
XTAP_TAPCELL_ROW_51_316 VSUBS _999_/VPB sky130_fd_sc_hd__tapvpwrvgnd_1
XFILLER_61_181 VSUBS VSUBS _999_/VPB _999_/VPB sky130_fd_sc_hd__decap_12
XFILLER_39_36 VSUBS VSUBS _999_/VPB _999_/VPB sky130_fd_sc_hd__decap_12
XFILLER_55_24 VSUBS VSUBS _999_/VPB _999_/VPB sky130_fd_sc_hd__decap_12
XFILLER_44_115 VSUBS VSUBS _999_/VPB _999_/VPB sky130_fd_sc_hd__decap_12
XFILLER_17_318 VSUBS VSUBS _999_/VPB _999_/VPB sky130_fd_sc_hd__decap_12
XFILLER_29_178 VSUBS VSUBS _999_/VPB _999_/VPB sky130_fd_sc_hd__fill_2
XFILLER_40_354 VSUBS VSUBS _999_/VPB _999_/VPB sky130_fd_sc_hd__decap_12
XFILLER_40_343 VSUBS VSUBS _999_/VPB _999_/VPB sky130_fd_sc_hd__decap_4
X_470_ _578_/A _469_/Y _465_/Y VSUBS VSUBS _999_/VPB _999_/VPB _983_/D sky130_fd_sc_hd__o21ai_0
XFILLER_4_211 VSUBS VSUBS _999_/VPB _999_/VPB sky130_fd_sc_hd__decap_8
X_806_ _806_/A _806_/B VSUBS VSUBS _999_/VPB _999_/VPB _953_/D sky130_fd_sc_hd__nor2_1
X_668_ _445_/Y _662_/Y _667_/Y VSUBS VSUBS _999_/VPB _999_/VPB _910_/D sky130_fd_sc_hd__a21oi_1
X_737_ _737_/A _749_/A VSUBS VSUBS _999_/VPB _999_/VPB _742_/A sky130_fd_sc_hd__xor2_1
X_599_ _599_/A _599_/B _599_/C _599_/D VSUBS VSUBS _999_/VPB _999_/VPB _599_/Y sky130_fd_sc_hd__nor4_1
XFILLER_35_159 VSUBS VSUBS _999_/VPB _999_/VPB sky130_fd_sc_hd__decap_12
XFILLER_35_137 VSUBS VSUBS _999_/VPB _999_/VPB sky130_fd_sc_hd__fill_1
XFILLER_16_351 VSUBS VSUBS _999_/VPB _999_/VPB sky130_fd_sc_hd__decap_12
XFILLER_26_115 VSUBS VSUBS _999_/VPB _999_/VPB sky130_fd_sc_hd__decap_12
XFILLER_22_343 VSUBS VSUBS _999_/VPB _999_/VPB sky130_fd_sc_hd__decap_6
XFILLER_41_48 VSUBS VSUBS _999_/VPB _999_/VPB sky130_fd_sc_hd__decap_12
X_522_ _976_/Q _523_/B VSUBS VSUBS _999_/VPB _999_/VPB _659_/B sky130_fd_sc_hd__and2_0
X_453_ ESPI_RESET_N rst_n VSUBS VSUBS _999_/VPB _999_/VPB _587_/C sky130_fd_sc_hd__and2_1
XFILLER_40_151 VSUBS VSUBS _999_/VPB _999_/VPB sky130_fd_sc_hd__decap_12
XFILLER_25_181 VSUBS VSUBS _999_/VPB _999_/VPB sky130_fd_sc_hd__decap_12
XFILLER_48_295 VSUBS VSUBS _999_/VPB _999_/VPB sky130_fd_sc_hd__decap_12
XFILLER_31_173 VSUBS VSUBS _999_/VPB _999_/VPB sky130_fd_sc_hd__decap_6
XFILLER_10_368 VSUBS VSUBS _999_/VPB _999_/VPB sky130_fd_sc_hd__fill_1
XFILLER_60_235 VSUBS VSUBS _999_/VPB _999_/VPB sky130_fd_sc_hd__decap_12
X_436_ _930_/Q VSUBS VSUBS _999_/VPB _999_/VPB _436_/Y sky130_fd_sc_hd__clkinv_1
XFILLER_45_265 VSUBS VSUBS _999_/VPB _999_/VPB sky130_fd_sc_hd__decap_8
X_505_ LAST_CMD[7] LAST_CMD[6] LAST_CMD[4] LAST_CMD[5] VSUBS VSUBS _999_/VPB _999_/VPB
+ _541_/C sky130_fd_sc_hd__or4b_1
XFILLER_42_91 VSUBS VSUBS _999_/VPB _999_/VPB sky130_fd_sc_hd__decap_12
XFILLER_9_133 VSUBS VSUBS _999_/VPB _999_/VPB sky130_fd_sc_hd__decap_12
XFILLER_5_361 VSUBS VSUBS _999_/VPB _999_/VPB sky130_fd_sc_hd__decap_8
XTAP_TAPCELL_ROW_38_238 VSUBS _999_/VPB sky130_fd_sc_hd__tapvpwrvgnd_1
XFILLER_3_85 VSUBS VSUBS _999_/VPB _999_/VPB sky130_fd_sc_hd__decap_12
XTAP_TAPCELL_ROW_46_282 VSUBS _999_/VPB sky130_fd_sc_hd__tapvpwrvgnd_1
XFILLER_59_313 VSUBS VSUBS _999_/VPB _999_/VPB sky130_fd_sc_hd__decap_8
XFILLER_47_36 VSUBS VSUBS _999_/VPB _999_/VPB sky130_fd_sc_hd__decap_12
XTAP_TAPCELL_ROW_12_83 VSUBS _999_/VPB sky130_fd_sc_hd__tapvpwrvgnd_1
XFILLER_42_279 VSUBS VSUBS _999_/VPB _999_/VPB sky130_fd_sc_hd__decap_6
XFILLER_6_147 VSUBS VSUBS _999_/VPB _999_/VPB sky130_fd_sc_hd__decap_3
XFILLER_6_103 VSUBS VSUBS _999_/VPB _999_/VPB sky130_fd_sc_hd__decap_12
XFILLER_5_0 VSUBS VSUBS _999_/VPB _999_/VPB sky130_fd_sc_hd__decap_12
XFILLER_2_331 VSUBS VSUBS _999_/VPB _999_/VPB sky130_fd_sc_hd__decap_8
X_985_ VSUBS VSUBS _999_/VPB _999_/VPB STATUS_REG[1] _985_/LO sky130_fd_sc_hd__conb_1
XTAP_TAPCELL_ROW_35_219 VSUBS _999_/VPB sky130_fd_sc_hd__tapvpwrvgnd_1
XFILLER_18_221 VSUBS VSUBS _999_/VPB _999_/VPB sky130_fd_sc_hd__decap_4
XFILLER_18_265 VSUBS VSUBS _999_/VPB _999_/VPB sky130_fd_sc_hd__decap_4
XFILLER_56_327 VSUBS VSUBS _999_/VPB _999_/VPB sky130_fd_sc_hd__decap_3
XFILLER_38_0 VSUBS VSUBS _999_/VPB _999_/VPB sky130_fd_sc_hd__decap_12
XFILLER_24_279 VSUBS VSUBS _999_/VPB _999_/VPB sky130_fd_sc_hd__fill_1
XFILLER_59_121 VSUBS VSUBS _999_/VPB _999_/VPB sky130_fd_sc_hd__decap_12
XFILLER_58_24 VSUBS VSUBS _999_/VPB _999_/VPB sky130_fd_sc_hd__decap_6
XFILLER_3_117 VSUBS VSUBS _999_/VPB _999_/VPB sky130_fd_sc_hd__decap_3
XFILLER_58_79 VSUBS VSUBS _999_/VPB _999_/VPB sky130_fd_sc_hd__decap_8
X_770_ _791_/B _774_/A VSUBS VSUBS _999_/VPB _999_/VPB _770_/Y sky130_fd_sc_hd__xnor2_1
XFILLER_15_257 VSUBS VSUBS _999_/VPB _999_/VPB sky130_fd_sc_hd__decap_3
X_968_ _969_/CLK _968_/D VSUBS VSUBS _999_/VPB _999_/VPB _968_/Q sky130_fd_sc_hd__dfxtp_1
XFILLER_0_31 VSUBS VSUBS _999_/VPB _999_/VPB sky130_fd_sc_hd__decap_12
X_899_ _981_/CLK _899_/D VSUBS VSUBS _999_/VPB _999_/VPB _899_/Q sky130_fd_sc_hd__dfxtp_1
XFILLER_9_73 VSUBS VSUBS _999_/VPB _999_/VPB sky130_fd_sc_hd__decap_12
XFILLER_29_305 VSUBS VSUBS _999_/VPB _999_/VPB sky130_fd_sc_hd__decap_12
XFILLER_8_209 VSUBS VSUBS _999_/VPB _999_/VPB sky130_fd_sc_hd__fill_1
XFILLER_12_227 VSUBS VSUBS _999_/VPB _999_/VPB sky130_fd_sc_hd__decap_12
XFILLER_20_271 VSUBS VSUBS _999_/VPB _999_/VPB sky130_fd_sc_hd__decap_12
X_822_ _959_/Q _822_/B VSUBS VSUBS _999_/VPB _999_/VPB _824_/A sky130_fd_sc_hd__nor2_1
X_753_ _753_/A _753_/B VSUBS VSUBS _999_/VPB _999_/VPB _754_/B sky130_fd_sc_hd__xnor2_1
XFILLER_47_179 VSUBS VSUBS _999_/VPB _999_/VPB sky130_fd_sc_hd__fill_1
XFILLER_47_157 VSUBS VSUBS _999_/VPB _999_/VPB sky130_fd_sc_hd__decap_8
XFILLER_43_330 VSUBS VSUBS _999_/VPB _999_/VPB sky130_fd_sc_hd__decap_12
X_684_ _978_/Q _682_/Y _683_/Y VSUBS VSUBS _999_/VPB _999_/VPB _703_/A sky130_fd_sc_hd__a21oi_1
XTAP_TAPCELL_ROW_5_41 VSUBS _999_/VPB sky130_fd_sc_hd__tapvpwrvgnd_1
XFILLER_11_293 VSUBS VSUBS _999_/VPB _999_/VPB sky130_fd_sc_hd__decap_6
XFILLER_50_91 VSUBS VSUBS _999_/VPB _999_/VPB sky130_fd_sc_hd__decap_12
XFILLER_7_253 VSUBS VSUBS _999_/VPB _999_/VPB sky130_fd_sc_hd__decap_12
XFILLER_61_193 VSUBS VSUBS _999_/VPB _999_/VPB sky130_fd_sc_hd__decap_12
XTAP_TAPCELL_ROW_51_317 VSUBS _999_/VPB sky130_fd_sc_hd__tapvpwrvgnd_1
XFILLER_46_190 VSUBS VSUBS _999_/VPB _999_/VPB sky130_fd_sc_hd__decap_12
XFILLER_39_48 VSUBS VSUBS _999_/VPB _999_/VPB sky130_fd_sc_hd__decap_12
XFILLER_55_36 VSUBS VSUBS _999_/VPB _999_/VPB sky130_fd_sc_hd__decap_12
XFILLER_44_127 VSUBS VSUBS _999_/VPB _999_/VPB sky130_fd_sc_hd__decap_6
XFILLER_25_341 VSUBS VSUBS _999_/VPB _999_/VPB sky130_fd_sc_hd__decap_6
XFILLER_52_171 VSUBS VSUBS _999_/VPB _999_/VPB sky130_fd_sc_hd__decap_12
XFILLER_40_366 VSUBS VSUBS _999_/VPB _999_/VPB sky130_fd_sc_hd__decap_3
XFILLER_40_322 VSUBS VSUBS _999_/VPB _999_/VPB sky130_fd_sc_hd__fill_2
X_736_ _932_/Q _949_/Q VSUBS VSUBS _999_/VPB _999_/VPB _749_/A sky130_fd_sc_hd__xor2_1
X_805_ ESPI_IO0_IN _803_/Y _459_/B VSUBS VSUBS _999_/VPB _999_/VPB _806_/B sky130_fd_sc_hd__o21ai_0
X_598_ _436_/Y _910_/Q _446_/Y _929_/Q _591_/Y VSUBS VSUBS _999_/VPB _999_/VPB _599_/D
+ sky130_fd_sc_hd__o221ai_1
X_667_ _947_/Q _662_/Y _459_/B VSUBS VSUBS _999_/VPB _999_/VPB _667_/Y sky130_fd_sc_hd__o21ai_0
XFILLER_16_363 VSUBS VSUBS _999_/VPB _999_/VPB sky130_fd_sc_hd__decap_6
XFILLER_20_0 VSUBS VSUBS _999_/VPB _999_/VPB sky130_fd_sc_hd__decap_12
XFILLER_26_127 VSUBS VSUBS _999_/VPB _999_/VPB sky130_fd_sc_hd__decap_12
XFILLER_22_355 VSUBS VSUBS _999_/VPB _999_/VPB sky130_fd_sc_hd__decap_12
XFILLER_1_237 VSUBS VSUBS _999_/VPB _999_/VPB sky130_fd_sc_hd__decap_3
X_521_ _970_/Q _975_/Q VSUBS VSUBS _999_/VPB _999_/VPB ESPI_IO1_OUT sky130_fd_sc_hd__nand2b_1
X_452_ _889_/Q VSUBS VSUBS _999_/VPB _999_/VPB ESPI_ALERT_N sky130_fd_sc_hd__clkinv_1
XFILLER_40_163 VSUBS VSUBS _999_/VPB _999_/VPB sky130_fd_sc_hd__decap_8
XTAP_TAPCELL_ROW_2_20 VSUBS _999_/VPB sky130_fd_sc_hd__tapvpwrvgnd_1
XFILLER_13_344 VSUBS VSUBS _999_/VPB _999_/VPB sky130_fd_sc_hd__decap_12
XFILLER_15_61 VSUBS VSUBS _999_/VPB _999_/VPB sky130_fd_sc_hd__decap_12
XFILLER_48_252 VSUBS VSUBS _999_/VPB _999_/VPB sky130_fd_sc_hd__fill_1
X_719_ _723_/A _719_/B VSUBS VSUBS _999_/VPB _999_/VPB _925_/D sky130_fd_sc_hd__nor2_1
XFILLER_39_241 VSUBS VSUBS _999_/VPB _999_/VPB sky130_fd_sc_hd__decap_12
XFILLER_54_211 VSUBS VSUBS _999_/VPB _999_/VPB sky130_fd_sc_hd__decap_12
XFILLER_6_329 VSUBS VSUBS _999_/VPB _999_/VPB sky130_fd_sc_hd__fill_1
XFILLER_60_247 VSUBS VSUBS _999_/VPB _999_/VPB sky130_fd_sc_hd__decap_12
X_504_ _978_/Q _504_/B VSUBS VSUBS _999_/VPB _999_/VPB _504_/Y sky130_fd_sc_hd__nand2_1
XFILLER_13_185 VSUBS VSUBS _999_/VPB _999_/VPB sky130_fd_sc_hd__decap_12
XFILLER_9_145 VSUBS VSUBS _999_/VPB _999_/VPB sky130_fd_sc_hd__decap_12
XFILLER_3_97 VSUBS VSUBS _999_/VPB _999_/VPB sky130_fd_sc_hd__decap_8
XTAP_TAPCELL_ROW_46_283 VSUBS _999_/VPB sky130_fd_sc_hd__tapvpwrvgnd_1
XTAP_TAPCELL_ROW_38_239 VSUBS _999_/VPB sky130_fd_sc_hd__tapvpwrvgnd_1
XFILLER_36_211 VSUBS VSUBS _999_/VPB _999_/VPB sky130_fd_sc_hd__decap_12
XFILLER_47_48 VSUBS VSUBS _999_/VPB _999_/VPB sky130_fd_sc_hd__decap_12
XFILLER_42_269 VSUBS VSUBS _999_/VPB _999_/VPB sky130_fd_sc_hd__fill_1
XFILLER_27_288 VSUBS VSUBS _999_/VPB _999_/VPB sky130_fd_sc_hd__decap_3
XFILLER_27_299 VSUBS VSUBS _999_/VPB _999_/VPB sky130_fd_sc_hd__fill_1
XFILLER_50_291 VSUBS VSUBS _999_/VPB _999_/VPB sky130_fd_sc_hd__fill_1
XFILLER_6_115 VSUBS VSUBS _999_/VPB _999_/VPB sky130_fd_sc_hd__decap_12
XFILLER_10_188 VSUBS VSUBS _999_/VPB _999_/VPB sky130_fd_sc_hd__decap_12
X_984_ VSUBS VSUBS _999_/VPB _999_/VPB STATUS_REG[0] _984_/LO sky130_fd_sc_hd__conb_1
XFILLER_18_211 VSUBS VSUBS _999_/VPB _999_/VPB sky130_fd_sc_hd__decap_6
XFILLER_18_288 VSUBS VSUBS _999_/VPB _999_/VPB sky130_fd_sc_hd__decap_8
XTAP_TAPCELL_ROW_43_264 VSUBS _999_/VPB sky130_fd_sc_hd__tapvpwrvgnd_1
XFILLER_41_291 VSUBS VSUBS _999_/VPB _999_/VPB sky130_fd_sc_hd__decap_8
XFILLER_5_181 VSUBS VSUBS _999_/VPB _999_/VPB sky130_fd_sc_hd__decap_12
XFILLER_56_339 VSUBS VSUBS _999_/VPB _999_/VPB sky130_fd_sc_hd__fill_2
XFILLER_24_225 VSUBS VSUBS _999_/VPB _999_/VPB sky130_fd_sc_hd__fill_2
XFILLER_59_133 VSUBS VSUBS _999_/VPB _999_/VPB sky130_fd_sc_hd__decap_12
XFILLER_59_177 VSUBS VSUBS _999_/VPB _999_/VPB sky130_fd_sc_hd__decap_3
XFILLER_55_361 VSUBS VSUBS _999_/VPB _999_/VPB sky130_fd_sc_hd__decap_8
XFILLER_23_61 VSUBS VSUBS _999_/VPB _999_/VPB sky130_fd_sc_hd__decap_12
XFILLER_48_91 VSUBS VSUBS _999_/VPB _999_/VPB sky130_fd_sc_hd__decap_12
XFILLER_38_317 VSUBS VSUBS _999_/VPB _999_/VPB sky130_fd_sc_hd__decap_12
XFILLER_2_151 VSUBS VSUBS _999_/VPB _999_/VPB sky130_fd_sc_hd__decap_12
X_967_ _969_/CLK _967_/D VSUBS VSUBS _999_/VPB _999_/VPB _967_/Q sky130_fd_sc_hd__dfxtp_1
X_898_ _981_/CLK _898_/D VSUBS VSUBS _999_/VPB _999_/VPB _898_/Q sky130_fd_sc_hd__dfxtp_1
XFILLER_61_331 VSUBS VSUBS _999_/VPB _999_/VPB sky130_fd_sc_hd__decap_12
XFILLER_0_43 VSUBS VSUBS _999_/VPB _999_/VPB sky130_fd_sc_hd__decap_12
XFILLER_9_85 VSUBS VSUBS _999_/VPB _999_/VPB sky130_fd_sc_hd__decap_12
XFILLER_21_239 VSUBS VSUBS _999_/VPB _999_/VPB sky130_fd_sc_hd__fill_1
XFILLER_50_0 VSUBS VSUBS _999_/VPB _999_/VPB sky130_fd_sc_hd__decap_12
XFILLER_56_103 VSUBS VSUBS _999_/VPB _999_/VPB sky130_fd_sc_hd__decap_12
XFILLER_37_361 VSUBS VSUBS _999_/VPB _999_/VPB sky130_fd_sc_hd__decap_8
XFILLER_29_339 VSUBS VSUBS _999_/VPB _999_/VPB sky130_fd_sc_hd__decap_6
XFILLER_29_317 VSUBS VSUBS _999_/VPB _999_/VPB sky130_fd_sc_hd__decap_12
XFILLER_52_331 VSUBS VSUBS _999_/VPB _999_/VPB sky130_fd_sc_hd__decap_6
XFILLER_12_239 VSUBS VSUBS _999_/VPB _999_/VPB sky130_fd_sc_hd__decap_8
XFILLER_20_283 VSUBS VSUBS _999_/VPB _999_/VPB sky130_fd_sc_hd__decap_4
X_821_ _821_/A _821_/B VSUBS VSUBS _999_/VPB _999_/VPB _958_/D sky130_fd_sc_hd__nor2_1
X_752_ _935_/Q _952_/Q VSUBS VSUBS _999_/VPB _999_/VPB _754_/A sky130_fd_sc_hd__xnor2_1
XFILLER_43_342 VSUBS VSUBS _999_/VPB _999_/VPB sky130_fd_sc_hd__decap_12
X_683_ _978_/Q _976_/Q _523_/B _496_/Y VSUBS VSUBS _999_/VPB _999_/VPB _683_/Y sky130_fd_sc_hd__o211ai_1
XFILLER_7_265 VSUBS VSUBS _999_/VPB _999_/VPB sky130_fd_sc_hd__decap_3
XFILLER_7_221 VSUBS VSUBS _999_/VPB _999_/VPB sky130_fd_sc_hd__decap_12
XFILLER_7_298 VSUBS VSUBS _999_/VPB _999_/VPB sky130_fd_sc_hd__fill_2
XFILLER_53_117 VSUBS VSUBS _999_/VPB _999_/VPB sky130_fd_sc_hd__decap_3
XFILLER_38_147 VSUBS VSUBS _999_/VPB _999_/VPB sky130_fd_sc_hd__decap_3
XFILLER_38_103 VSUBS VSUBS _999_/VPB _999_/VPB sky130_fd_sc_hd__decap_12
XFILLER_19_361 VSUBS VSUBS _999_/VPB _999_/VPB sky130_fd_sc_hd__decap_8
XFILLER_34_331 VSUBS VSUBS _999_/VPB _999_/VPB sky130_fd_sc_hd__decap_12
XFILLER_55_48 VSUBS VSUBS _999_/VPB _999_/VPB sky130_fd_sc_hd__decap_12
XFILLER_40_301 VSUBS VSUBS _999_/VPB _999_/VPB sky130_fd_sc_hd__decap_12
XFILLER_52_183 VSUBS VSUBS _999_/VPB _999_/VPB sky130_fd_sc_hd__decap_12
X_735_ _759_/S _733_/X _734_/Y VSUBS VSUBS _999_/VPB _999_/VPB _929_/D sky130_fd_sc_hd__a21oi_1
X_804_ _953_/Q _822_/B VSUBS VSUBS _999_/VPB _999_/VPB _806_/A sky130_fd_sc_hd__nor2_1
XFILLER_35_117 VSUBS VSUBS _999_/VPB _999_/VPB sky130_fd_sc_hd__decap_3
X_666_ _446_/Y _662_/Y _665_/Y VSUBS VSUBS _999_/VPB _999_/VPB _909_/D sky130_fd_sc_hd__a21oi_1
X_597_ _597_/A _597_/B VSUBS VSUBS _999_/VPB _999_/VPB _599_/C sky130_fd_sc_hd__nand2_1
XFILLER_31_301 VSUBS VSUBS _999_/VPB _999_/VPB sky130_fd_sc_hd__decap_12
XFILLER_16_331 VSUBS VSUBS _999_/VPB _999_/VPB sky130_fd_sc_hd__decap_12
XFILLER_61_91 VSUBS VSUBS _999_/VPB _999_/VPB sky130_fd_sc_hd__decap_12
XFILLER_6_31 VSUBS VSUBS _999_/VPB _999_/VPB sky130_fd_sc_hd__decap_12
XFILLER_3_290 VSUBS VSUBS _999_/VPB _999_/VPB sky130_fd_sc_hd__decap_8
XFILLER_41_109 VSUBS VSUBS _999_/VPB _999_/VPB sky130_fd_sc_hd__decap_8
XFILLER_13_0 VSUBS VSUBS _999_/VPB _999_/VPB sky130_fd_sc_hd__decap_12
XFILLER_22_301 VSUBS VSUBS _999_/VPB _999_/VPB sky130_fd_sc_hd__decap_12
XFILLER_26_139 VSUBS VSUBS _999_/VPB _999_/VPB sky130_fd_sc_hd__decap_8
XFILLER_22_367 VSUBS VSUBS _999_/VPB _999_/VPB sky130_fd_sc_hd__fill_2
XFILLER_1_205 VSUBS VSUBS _999_/VPB _999_/VPB sky130_fd_sc_hd__decap_12
XFILLER_57_286 VSUBS VSUBS _999_/VPB _999_/VPB sky130_fd_sc_hd__fill_1
XFILLER_17_117 VSUBS VSUBS _999_/VPB _999_/VPB sky130_fd_sc_hd__decap_3
X_520_ _520_/A _520_/B VSUBS VSUBS _999_/VPB _999_/VPB _976_/D sky130_fd_sc_hd__nand2_1
XFILLER_13_356 VSUBS VSUBS _999_/VPB _999_/VPB sky130_fd_sc_hd__decap_4
XFILLER_15_73 VSUBS VSUBS _999_/VPB _999_/VPB sky130_fd_sc_hd__decap_12
X_451_ _983_/Q VSUBS VSUBS _999_/VPB _999_/VPB _578_/A sky130_fd_sc_hd__clkinv_1
XFILLER_31_61 VSUBS VSUBS _999_/VPB _999_/VPB sky130_fd_sc_hd__decap_12
XTAP_TAPCELL_ROW_2_21 VSUBS _999_/VPB sky130_fd_sc_hd__tapvpwrvgnd_1
XFILLER_0_271 VSUBS VSUBS _999_/VPB _999_/VPB sky130_fd_sc_hd__decap_12
XFILLER_56_91 VSUBS VSUBS _999_/VPB _999_/VPB sky130_fd_sc_hd__decap_12
X_649_ LAST_CMD[3] _659_/B VSUBS VSUBS _999_/VPB _999_/VPB _651_/A sky130_fd_sc_hd__nor2_1
X_718_ _925_/Q _950_/Q _722_/S VSUBS VSUBS _999_/VPB _999_/VPB _719_/B sky130_fd_sc_hd__mux2i_1
XFILLER_23_109 VSUBS VSUBS _999_/VPB _999_/VPB sky130_fd_sc_hd__decap_8
XFILLER_39_286 VSUBS VSUBS _999_/VPB _999_/VPB sky130_fd_sc_hd__decap_12
XFILLER_39_253 VSUBS VSUBS _999_/VPB _999_/VPB sky130_fd_sc_hd__decap_8
XFILLER_54_267 VSUBS VSUBS _999_/VPB _999_/VPB sky130_fd_sc_hd__decap_3
XFILLER_54_223 VSUBS VSUBS _999_/VPB _999_/VPB sky130_fd_sc_hd__decap_12
X_503_ _503_/A _503_/B _503_/C VSUBS VSUBS _999_/VPB _999_/VPB _979_/D sky130_fd_sc_hd__nand3_1
XFILLER_60_259 VSUBS VSUBS _999_/VPB _999_/VPB sky130_fd_sc_hd__decap_8
XFILLER_9_157 VSUBS VSUBS _999_/VPB _999_/VPB sky130_fd_sc_hd__decap_6
XFILLER_13_197 VSUBS VSUBS _999_/VPB _999_/VPB sky130_fd_sc_hd__decap_12
XFILLER_36_201 VSUBS VSUBS _999_/VPB _999_/VPB sky130_fd_sc_hd__decap_8
XTAP_TAPCELL_ROW_46_284 VSUBS _999_/VPB sky130_fd_sc_hd__tapvpwrvgnd_1
XFILLER_36_223 VSUBS VSUBS _999_/VPB _999_/VPB sky130_fd_sc_hd__decap_12
XFILLER_27_223 VSUBS VSUBS _999_/VPB _999_/VPB sky130_fd_sc_hd__fill_1
XFILLER_27_245 VSUBS VSUBS _999_/VPB _999_/VPB sky130_fd_sc_hd__fill_1
XFILLER_6_127 VSUBS VSUBS _999_/VPB _999_/VPB sky130_fd_sc_hd__decap_12
XFILLER_2_366 VSUBS VSUBS _999_/VPB _999_/VPB sky130_fd_sc_hd__decap_3
X_983_ _983_/CLK _983_/D VSUBS VSUBS _999_/VPB _999_/VPB _983_/Q sky130_fd_sc_hd__dfxtp_1
XTAP_TAPCELL_ROW_43_265 VSUBS _999_/VPB sky130_fd_sc_hd__tapvpwrvgnd_1
XFILLER_5_193 VSUBS VSUBS _999_/VPB _999_/VPB sky130_fd_sc_hd__decap_12
XFILLER_56_307 VSUBS VSUBS _999_/VPB _999_/VPB sky130_fd_sc_hd__decap_12
XTAP_TAPCELL_ROW_34_210 VSUBS _999_/VPB sky130_fd_sc_hd__tapvpwrvgnd_1
XFILLER_59_145 VSUBS VSUBS _999_/VPB _999_/VPB sky130_fd_sc_hd__decap_12
XTAP_TAPCELL_ROW_40_246 VSUBS _999_/VPB sky130_fd_sc_hd__tapvpwrvgnd_1
XFILLER_30_207 VSUBS VSUBS _999_/VPB _999_/VPB sky130_fd_sc_hd__decap_3
XFILLER_23_73 VSUBS VSUBS _999_/VPB _999_/VPB sky130_fd_sc_hd__decap_12
XFILLER_2_163 VSUBS VSUBS _999_/VPB _999_/VPB sky130_fd_sc_hd__decap_12
XFILLER_38_329 VSUBS VSUBS _999_/VPB _999_/VPB sky130_fd_sc_hd__fill_1
X_966_ _969_/CLK _966_/D VSUBS VSUBS _999_/VPB _999_/VPB _966_/Q sky130_fd_sc_hd__dfxtp_1
X_897_ _981_/CLK _897_/D VSUBS VSUBS _999_/VPB _999_/VPB _897_/Q sky130_fd_sc_hd__dfxtp_1
XFILLER_61_343 VSUBS VSUBS _999_/VPB _999_/VPB sky130_fd_sc_hd__decap_12
XFILLER_0_55 VSUBS VSUBS _999_/VPB _999_/VPB sky130_fd_sc_hd__decap_4
XFILLER_9_97 VSUBS VSUBS _999_/VPB _999_/VPB sky130_fd_sc_hd__decap_12
XFILLER_43_0 VSUBS VSUBS _999_/VPB _999_/VPB sky130_fd_sc_hd__decap_12
XFILLER_56_115 VSUBS VSUBS _999_/VPB _999_/VPB sky130_fd_sc_hd__decap_12
XFILLER_52_310 VSUBS VSUBS _999_/VPB _999_/VPB sky130_fd_sc_hd__decap_12
XFILLER_29_329 VSUBS VSUBS _999_/VPB _999_/VPB sky130_fd_sc_hd__decap_3
XFILLER_12_207 VSUBS VSUBS _999_/VPB _999_/VPB sky130_fd_sc_hd__decap_3
Xclkbuf_3_0__f_clk clkbuf_0_clk/X VSUBS VSUBS _999_/VPB _999_/VPB _983_/CLK sky130_fd_sc_hd__clkbuf_16
X_751_ _759_/S _749_/Y _750_/Y VSUBS VSUBS _999_/VPB _999_/VPB _932_/D sky130_fd_sc_hd__a21oi_1
X_820_ _957_/Q _803_/Y _459_/B VSUBS VSUBS _999_/VPB _999_/VPB _821_/B sky130_fd_sc_hd__o21ai_0
X_682_ LAST_CMD[0] _682_/B VSUBS VSUBS _999_/VPB _999_/VPB _682_/Y sky130_fd_sc_hd__nand2_1
XFILLER_55_181 VSUBS VSUBS _999_/VPB _999_/VPB sky130_fd_sc_hd__decap_12
XFILLER_55_170 VSUBS VSUBS _999_/VPB _999_/VPB sky130_fd_sc_hd__fill_1
XFILLER_43_354 VSUBS VSUBS _999_/VPB _999_/VPB sky130_fd_sc_hd__decap_6
XFILLER_7_233 VSUBS VSUBS _999_/VPB _999_/VPB sky130_fd_sc_hd__decap_6
X_949_ _959_/CLK _956_/Q _461_/X VSUBS VSUBS _999_/VPB _999_/VPB _949_/Q sky130_fd_sc_hd__edfxtp_1
XFILLER_38_115 VSUBS VSUBS _999_/VPB _999_/VPB sky130_fd_sc_hd__decap_12
XFILLER_34_343 VSUBS VSUBS _999_/VPB _999_/VPB sky130_fd_sc_hd__fill_1
XFILLER_34_321 VSUBS VSUBS _999_/VPB _999_/VPB sky130_fd_sc_hd__decap_8
XFILLER_61_151 VSUBS VSUBS _999_/VPB _999_/VPB sky130_fd_sc_hd__decap_12
XFILLER_52_195 VSUBS VSUBS _999_/VPB _999_/VPB sky130_fd_sc_hd__decap_12
XFILLER_52_151 VSUBS VSUBS _999_/VPB _999_/VPB sky130_fd_sc_hd__fill_1
XFILLER_40_313 VSUBS VSUBS _999_/VPB _999_/VPB sky130_fd_sc_hd__decap_6
XFILLER_37_181 VSUBS VSUBS _999_/VPB _999_/VPB sky130_fd_sc_hd__decap_12
X_734_ _929_/Q _759_/S _873_/B VSUBS VSUBS _999_/VPB _999_/VPB _734_/Y sky130_fd_sc_hd__o21ai_0
X_665_ _946_/Q _662_/Y _459_/B VSUBS VSUBS _999_/VPB _999_/VPB _665_/Y sky130_fd_sc_hd__o21ai_0
X_803_ ESPI_CS_N ESPI_BIT_TICK VSUBS VSUBS _999_/VPB _999_/VPB _803_/Y sky130_fd_sc_hd__nand2b_1
XFILLER_16_310 VSUBS VSUBS _999_/VPB _999_/VPB sky130_fd_sc_hd__decap_12
XFILLER_28_181 VSUBS VSUBS _999_/VPB _999_/VPB sky130_fd_sc_hd__decap_12
XFILLER_29_61 VSUBS VSUBS _999_/VPB _999_/VPB sky130_fd_sc_hd__decap_12
X_596_ _596_/A _596_/B VSUBS VSUBS _999_/VPB _999_/VPB _599_/B sky130_fd_sc_hd__nand2_1
XFILLER_31_357 VSUBS VSUBS _999_/VPB _999_/VPB sky130_fd_sc_hd__decap_3
XFILLER_31_313 VSUBS VSUBS _999_/VPB _999_/VPB sky130_fd_sc_hd__decap_12
XFILLER_16_343 VSUBS VSUBS _999_/VPB _999_/VPB sky130_fd_sc_hd__decap_4
XFILLER_6_87 VSUBS VSUBS _999_/VPB _999_/VPB sky130_fd_sc_hd__decap_3
XFILLER_6_43 VSUBS VSUBS _999_/VPB _999_/VPB sky130_fd_sc_hd__decap_12
XFILLER_34_151 VSUBS VSUBS _999_/VPB _999_/VPB sky130_fd_sc_hd__decap_12
XFILLER_19_192 VSUBS VSUBS _999_/VPB _999_/VPB sky130_fd_sc_hd__fill_1
XFILLER_22_313 VSUBS VSUBS _999_/VPB _999_/VPB sky130_fd_sc_hd__decap_12
XFILLER_1_217 VSUBS VSUBS _999_/VPB _999_/VPB sky130_fd_sc_hd__decap_12
XTAP_TAPCELL_ROW_15_96 VSUBS _999_/VPB sky130_fd_sc_hd__tapvpwrvgnd_1
XFILLER_57_298 VSUBS VSUBS _999_/VPB _999_/VPB sky130_fd_sc_hd__fill_2
X_450_ _874_/Q VSUBS VSUBS _999_/VPB _999_/VPB _524_/A sky130_fd_sc_hd__clkinv_1
XFILLER_15_85 VSUBS VSUBS _999_/VPB _999_/VPB sky130_fd_sc_hd__decap_12
XTAP_TAPCELL_ROW_27_168 VSUBS _999_/VPB sky130_fd_sc_hd__tapvpwrvgnd_1
XFILLER_31_73 VSUBS VSUBS _999_/VPB _999_/VPB sky130_fd_sc_hd__decap_12
XTAP_TAPCELL_ROW_2_22 VSUBS _999_/VPB sky130_fd_sc_hd__tapvpwrvgnd_1
Xspare_nor2_0 spare_nor2_0/A spare_nor2_0/B VSUBS VSUBS _999_/VPB _999_/VPB spare_nor2_0/Y
+ sky130_fd_sc_hd__nor2_1
XFILLER_0_283 VSUBS VSUBS _999_/VPB _999_/VPB sky130_fd_sc_hd__decap_12
X_648_ _648_/A _648_/B VSUBS VSUBS _999_/VPB _999_/VPB _902_/D sky130_fd_sc_hd__nor2_1
X_717_ _439_/Y _722_/S _716_/Y _723_/A VSUBS VSUBS _999_/VPB _999_/VPB _924_/D sky130_fd_sc_hd__a211oi_1
XFILLER_16_151 VSUBS VSUBS _999_/VPB _999_/VPB sky130_fd_sc_hd__decap_12
XFILLER_31_165 VSUBS VSUBS _999_/VPB _999_/VPB sky130_fd_sc_hd__fill_2
XFILLER_31_121 VSUBS VSUBS _999_/VPB _999_/VPB sky130_fd_sc_hd__decap_12
XFILLER_8_361 VSUBS VSUBS _999_/VPB _999_/VPB sky130_fd_sc_hd__decap_8
X_579_ _885_/Q _578_/C _578_/Y _940_/Q VSUBS VSUBS _999_/VPB _999_/VPB _580_/B sky130_fd_sc_hd__a22oi_1
XFILLER_54_235 VSUBS VSUBS _999_/VPB _999_/VPB sky130_fd_sc_hd__decap_12
XFILLER_39_298 VSUBS VSUBS _999_/VPB _999_/VPB sky130_fd_sc_hd__fill_2
XFILLER_22_198 VSUBS VSUBS _999_/VPB _999_/VPB sky130_fd_sc_hd__decap_4
X_502_ _977_/Q _538_/B _502_/C VSUBS VSUBS _999_/VPB _999_/VPB _503_/C sky130_fd_sc_hd__nand3_1
XFILLER_13_121 VSUBS VSUBS _999_/VPB _999_/VPB sky130_fd_sc_hd__decap_12
XFILLER_5_320 VSUBS VSUBS _999_/VPB _999_/VPB sky130_fd_sc_hd__decap_12
XFILLER_3_22 VSUBS VSUBS _999_/VPB _999_/VPB sky130_fd_sc_hd__decap_12
XFILLER_36_235 VSUBS VSUBS _999_/VPB _999_/VPB sky130_fd_sc_hd__decap_12
XFILLER_51_249 VSUBS VSUBS _999_/VPB _999_/VPB sky130_fd_sc_hd__fill_1
XTAP_TAPCELL_ROW_46_285 VSUBS _999_/VPB sky130_fd_sc_hd__tapvpwrvgnd_1
XFILLER_8_191 VSUBS VSUBS _999_/VPB _999_/VPB sky130_fd_sc_hd__decap_12
XTAP_TAPCELL_ROW_37_230 VSUBS _999_/VPB sky130_fd_sc_hd__tapvpwrvgnd_1
XFILLER_27_268 VSUBS VSUBS _999_/VPB _999_/VPB sky130_fd_sc_hd__decap_12
XTAP_TAPCELL_ROW_20_130 VSUBS _999_/VPB sky130_fd_sc_hd__tapvpwrvgnd_1
XFILLER_6_139 VSUBS VSUBS _999_/VPB _999_/VPB sky130_fd_sc_hd__decap_8
XFILLER_12_31 VSUBS VSUBS _999_/VPB _999_/VPB sky130_fd_sc_hd__decap_12
XFILLER_58_360 VSUBS VSUBS _999_/VPB _999_/VPB sky130_fd_sc_hd__decap_8
X_982_ _982_/CLK _982_/D VSUBS VSUBS _999_/VPB _999_/VPB _982_/Q sky130_fd_sc_hd__dfxtp_1
XTAP_TAPCELL_ROW_43_266 VSUBS _999_/VPB sky130_fd_sc_hd__tapvpwrvgnd_1
XFILLER_37_61 VSUBS VSUBS _999_/VPB _999_/VPB sky130_fd_sc_hd__decap_12
XTAP_TAPCELL_ROW_8_54 VSUBS _999_/VPB sky130_fd_sc_hd__tapvpwrvgnd_1
XFILLER_56_319 VSUBS VSUBS _999_/VPB _999_/VPB sky130_fd_sc_hd__decap_8
XTAP_TAPCELL_ROW_34_211 VSUBS _999_/VPB sky130_fd_sc_hd__tapvpwrvgnd_1
XFILLER_32_271 VSUBS VSUBS _999_/VPB _999_/VPB sky130_fd_sc_hd__decap_3
XFILLER_3_109 VSUBS VSUBS _999_/VPB _999_/VPB sky130_fd_sc_hd__decap_8
XFILLER_59_157 VSUBS VSUBS _999_/VPB _999_/VPB sky130_fd_sc_hd__decap_12
XTAP_TAPCELL_ROW_40_247 VSUBS _999_/VPB sky130_fd_sc_hd__tapvpwrvgnd_1
XFILLER_23_85 VSUBS VSUBS _999_/VPB _999_/VPB sky130_fd_sc_hd__decap_12
XFILLER_3_0 VSUBS VSUBS _999_/VPB _999_/VPB sky130_fd_sc_hd__decap_12
XFILLER_2_175 VSUBS VSUBS _999_/VPB _999_/VPB sky130_fd_sc_hd__decap_12
X_965_ _969_/CLK _965_/D VSUBS VSUBS _999_/VPB _999_/VPB _965_/Q sky130_fd_sc_hd__dfxtp_1
XFILLER_0_12 VSUBS VSUBS _999_/VPB _999_/VPB sky130_fd_sc_hd__decap_12
X_896_ _981_/CLK _896_/D VSUBS VSUBS _999_/VPB _999_/VPB _896_/Q sky130_fd_sc_hd__dfxtp_1
XFILLER_61_355 VSUBS VSUBS _999_/VPB _999_/VPB sky130_fd_sc_hd__decap_4
XFILLER_0_89 VSUBS VSUBS _999_/VPB _999_/VPB sky130_fd_sc_hd__fill_1
XFILLER_14_271 VSUBS VSUBS _999_/VPB _999_/VPB sky130_fd_sc_hd__decap_8
XFILLER_56_127 VSUBS VSUBS _999_/VPB _999_/VPB sky130_fd_sc_hd__decap_12
XFILLER_36_0 VSUBS VSUBS _999_/VPB _999_/VPB sky130_fd_sc_hd__decap_12
XFILLER_52_366 VSUBS VSUBS _999_/VPB _999_/VPB sky130_fd_sc_hd__decap_3
XFILLER_52_322 VSUBS VSUBS _999_/VPB _999_/VPB sky130_fd_sc_hd__decap_8
X_750_ _932_/Q _759_/S _873_/B VSUBS VSUBS _999_/VPB _999_/VPB _750_/Y sky130_fd_sc_hd__o21ai_0
X_681_ _927_/Q _437_/Y _924_/Q _680_/Y _978_/Q VSUBS VSUBS _999_/VPB _999_/VPB _685_/A
+ sky130_fd_sc_hd__o41ai_1
XFILLER_55_193 VSUBS VSUBS _999_/VPB _999_/VPB sky130_fd_sc_hd__decap_12
XFILLER_43_311 VSUBS VSUBS _999_/VPB _999_/VPB sky130_fd_sc_hd__decap_3
XFILLER_11_241 VSUBS VSUBS _999_/VPB _999_/VPB sky130_fd_sc_hd__decap_6
X_948_ _959_/CLK _955_/Q _461_/X VSUBS VSUBS _999_/VPB _999_/VPB _948_/Q sky130_fd_sc_hd__edfxtp_1
XFILLER_38_127 VSUBS VSUBS _999_/VPB _999_/VPB sky130_fd_sc_hd__decap_4
X_879_ _969_/CLK _879_/D VSUBS VSUBS _999_/VPB _999_/VPB _879_/Q sky130_fd_sc_hd__dfxtp_1
XFILLER_61_163 VSUBS VSUBS _999_/VPB _999_/VPB sky130_fd_sc_hd__decap_12
XFILLER_40_347 VSUBS VSUBS _999_/VPB _999_/VPB sky130_fd_sc_hd__fill_1
XFILLER_37_193 VSUBS VSUBS _999_/VPB _999_/VPB sky130_fd_sc_hd__decap_4
XFILLER_20_31 VSUBS VSUBS _999_/VPB _999_/VPB sky130_fd_sc_hd__decap_12
X_802_ ESPI_BIT_TICK ESPI_CS_N VSUBS VSUBS _999_/VPB _999_/VPB _822_/B sky130_fd_sc_hd__lpflow_isobufsrc_1
X_733_ _733_/A _737_/A VSUBS VSUBS _999_/VPB _999_/VPB _733_/X sky130_fd_sc_hd__xor2_1
X_664_ _447_/Y _662_/Y _663_/Y VSUBS VSUBS _999_/VPB _999_/VPB _908_/D sky130_fd_sc_hd__a21oi_1
XFILLER_45_61 VSUBS VSUBS _999_/VPB _999_/VPB sky130_fd_sc_hd__decap_12
X_595_ _934_/Q _914_/Q VSUBS VSUBS _999_/VPB _999_/VPB _596_/B sky130_fd_sc_hd__xnor2_1
XFILLER_16_322 VSUBS VSUBS _999_/VPB _999_/VPB sky130_fd_sc_hd__decap_4
XFILLER_28_193 VSUBS VSUBS _999_/VPB _999_/VPB sky130_fd_sc_hd__decap_12
XFILLER_29_73 VSUBS VSUBS _999_/VPB _999_/VPB sky130_fd_sc_hd__decap_12
XFILLER_31_325 VSUBS VSUBS _999_/VPB _999_/VPB sky130_fd_sc_hd__decap_12
XFILLER_6_55 VSUBS VSUBS _999_/VPB _999_/VPB sky130_fd_sc_hd__decap_12
XFILLER_34_163 VSUBS VSUBS _999_/VPB _999_/VPB sky130_fd_sc_hd__decap_12
XFILLER_22_325 VSUBS VSUBS _999_/VPB _999_/VPB sky130_fd_sc_hd__decap_4
XFILLER_1_229 VSUBS VSUBS _999_/VPB _999_/VPB sky130_fd_sc_hd__decap_8
XTAP_TAPCELL_ROW_15_97 VSUBS _999_/VPB sky130_fd_sc_hd__tapvpwrvgnd_1
XFILLER_40_188 VSUBS VSUBS _999_/VPB _999_/VPB sky130_fd_sc_hd__decap_12
XFILLER_15_97 VSUBS VSUBS _999_/VPB _999_/VPB sky130_fd_sc_hd__decap_12
XFILLER_25_196 VSUBS VSUBS _999_/VPB _999_/VPB sky130_fd_sc_hd__decap_4
XTAP_TAPCELL_ROW_27_169 VSUBS _999_/VPB sky130_fd_sc_hd__tapvpwrvgnd_1
XFILLER_31_85 VSUBS VSUBS _999_/VPB _999_/VPB sky130_fd_sc_hd__decap_12
XTAP_TAPCELL_ROW_2_23 VSUBS _999_/VPB sky130_fd_sc_hd__tapvpwrvgnd_1
Xspare_nor2_1 spare_nor2_1/A spare_nor2_1/B VSUBS VSUBS _999_/VPB _999_/VPB spare_nor2_1/Y
+ sky130_fd_sc_hd__nor2_1
XFILLER_48_222 VSUBS VSUBS _999_/VPB _999_/VPB sky130_fd_sc_hd__decap_12
X_716_ _924_/Q _722_/S VSUBS VSUBS _999_/VPB _999_/VPB _716_/Y sky130_fd_sc_hd__nor2_1
XFILLER_0_295 VSUBS VSUBS _999_/VPB _999_/VPB sky130_fd_sc_hd__decap_4
X_647_ _947_/Q _526_/C _459_/B VSUBS VSUBS _999_/VPB _999_/VPB _648_/B sky130_fd_sc_hd__o21ai_0
XFILLER_31_133 VSUBS VSUBS _999_/VPB _999_/VPB sky130_fd_sc_hd__decap_12
XFILLER_16_163 VSUBS VSUBS _999_/VPB _999_/VPB sky130_fd_sc_hd__decap_12
X_578_ _578_/A _578_/B _578_/C VSUBS VSUBS _999_/VPB _999_/VPB _578_/Y sky130_fd_sc_hd__nor3_1
XTAP_TAPCELL_ROW_18_114 VSUBS _999_/VPB sky130_fd_sc_hd__tapvpwrvgnd_1
.ends
