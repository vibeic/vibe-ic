// SystemRDL 2.0 — generated by l4_systemrdl_export.py (vibe-ic#377 B).
// SOURCE: benchmark-data/ic/ibex/phase1/generated_docs/L4_REGMAP.json
//
// THIS FILE IS NOT A COMPLETE DESCRIPTION OF THE SOURCE REGISTER MAP.
//     53 L4 statements had NO SystemRDL construct and are absent here
//    277 landed WEAKER, STRONGER or DIFFERENT than the source said
//    236 are carried only through user-defined properties
// Every one is named, with a reason, in the companion ledger JSON.
// Reading this file without the ledger will overstate what is known.
//
// address unit: byte (as stated in L4)

property l4_purpose { type = string; component = reg; };
property l4_structure_summary { type = string; component = reg; };
property l4_sub_address_hex { type = string; component = reg; };
property l4_reset_value_kind { type = string; component = reg; };
property l4_reset_value_source { type = string; component = reg; };
property l4_is_counter { type = boolean; component = reg; };
property l4_kind { type = string; component = reg; };
property l4_endpoint { type = string; component = reg; };
property l4_range { type = string; component = reg; };
property l4_low_confidence { type = boolean; component = reg; };
property l4_role { type = string; component = reg; };
property l4_scope { type = string; component = reg; };
property l4_ap_or_dp { type = string; component = reg; };
property l4_regad { type = string; component = reg; };
property l4_dlab { type = string; component = reg; };
property l4_capture_value { type = string; component = reg; };
property l4_compute_rule { type = string; component = reg; };
property l4_common_values_hex { type = string; component = reg; };
property l4_common_values_hex_lsb_first { type = string; component = reg; };
property l4_evidence { type = string; component = reg | field; };
property l4_evidence_line { type = string; component = reg | field; };
property l4_extraction_strategy { type = string; component = reg | field; };
property l4_access_literal { type = string; component = reg | field; };
property l4_access_inherited { type = boolean; component = field; };
property l4_synthesised_whole_register_field { type = boolean; component = field; };
property l4_synthesised_source { type = string; component = field; };
property l4_feature_address { type = string; component = field; };

enum tdata1_BITS_31_28_e {
    Address = 4'b0010 { desc = "Address"; };
    Only = 4'b0001 { desc = "Only"; };
    Only_0000 = 4'b0000 { desc = "Only"; };
};
enum tdata1_BITS_26_21_e {
    Address = 6'b000010 { desc = "Address"; };
    Only = 6'b000001 { desc = "Only"; };
    Only_000000 = 6'b000000 { desc = "Only"; };
};
enum tdata1_BITS_17_16_e {
    Address = 2'b10 { desc = "Address"; };
    Only = 2'b01 { desc = "Only"; };
    Only_00 = 2'b00 { desc = "Only"; };
};
enum tdata1_BITS_15_12_e {
    Address = 4'b0010 { desc = "Address"; };
    Only = 4'b0001 { desc = "Only"; };
    Only_0000 = 4'b0000 { desc = "Only"; };
};
enum tdata1_BITS_10_7_e {
    Address = 4'b0010 { desc = "Address"; };
    Only = 4'b0001 { desc = "Only"; };
    Only_0000 = 4'b0000 { desc = "Only"; };
};
enum dcsr_BITS_31_28_e {
    External_ = 4'b0100 { desc = "External"; };
};
enum dcsr_BITS_8_6_e {
    External_ = 3'b100 { desc = "External"; };
};

addrmap ibex {
    desc = "Module memory map per spec. Reads from reserved bits return zeros and writes to reserved bits have no effect.";
    reg {
        regwidth = 32;
        desc = "Machine Status";
        l4_evidence = "input/docs/ibex_cs_registers.rst";
        l4_extraction_strategy = "rst_grid_csr_v1_6_566";
        l4_reset_value_kind = "numeric";
        l4_access_literal = "WARL";
        field { sw = rw; reset = 1'h0; desc = "Timeout Wait (WFI executed in User Mode will trap to Machine Mode)."; l4_access_literal = "RW"; } TW[21:21];
        field { sw = rw; reset = 1'h0; desc = "Modify Privilege (Loads and stores use MPP for privilege checking)."; l4_access_literal = "RW"; } MPRV[17:17];
        field { sw = rw; reset = 2'h0; desc = "Machine Previous Privilege mode."; l4_access_literal = "RW"; } MPP[12:11];
        field { sw = rw; reset = 1'h1; desc = "**Previous Interrupt Enable (MPIE)**, i.e., before entering exception handling."; l4_extraction_strategy = "asciidoc_rowspan_fields_acronym_tier0_v1_6_377_via_rst_bitfield_v1_6_408"; l4_access_literal = "RW"; } MPIE[7:7];
        field { sw = rw; reset = 1'h0; desc = "**Interrupt Enable (MIE):** If set to 1'b1, interrupts are globally enabled."; l4_extraction_strategy = "asciidoc_rowspan_fields_acronym_tier1_v1_6_377_via_rst_bitfield_v1_6_408"; l4_access_literal = "RW"; } MIE[3:3];
    } mstatus @ 0x300;
    reg {
        regwidth = 32;
        desc = "Machine Interrupt Enable Register";
        l4_evidence = "input/docs/ibex_cs_registers.rst";
        l4_extraction_strategy = "rst_grid_csr_v1_6_566";
        l4_reset_value_kind = "numeric";
        l4_access_literal = "WARL";
        field { sw = rw; reset = 15'h0; desc = "Machine Fast Interrupt Enables: Set bit x+16 to enable"; l4_access_inherited = true; l4_extraction_strategy = "asciidoc_rowspan_fields_bits_fallback"; l4_access_literal = "WARL"; } BITS_30_16[30:16];
        field { sw = rw; reset = 1'h0; desc = "If set, ``irq_external_i`` is enabled."; l4_access_inherited = true; l4_access_literal = "WARL"; } MEIE[11:11];
        field { sw = rw; reset = 1'h0; desc = "If set, ``irq_timer_i`` is enabled."; l4_access_inherited = true; l4_access_literal = "WARL"; } MTIE[7:7];
        field { sw = rw; reset = 1'h0; desc = "if set, ``irq_software_i`` is enabled."; l4_access_inherited = true; l4_access_literal = "WARL"; } MSIE[3:3];
    } mie @ 0x304;
    reg {
        regwidth = 32;
        desc = "Machine Counter-Inhibit Register";
        l4_evidence = "input/docs/ibex_cs_registers.rst";
        l4_extraction_strategy = "rst_grid_csr_v1_6_566";
        l4_is_counter = true;
        l4_access_literal = "RW";
        field { sw = rw; desc = "Machine Counter-Inhibit Register"; l4_access_inherited = true; l4_synthesised_source = "summary_table_only"; l4_synthesised_whole_register_field = true; l4_access_literal = "RW"; } WHOLE_REG[31:0];
    } mcountinhibit @ 0x320;
    reg {
        regwidth = 32;
        desc = "Machine Performance-Monitoring Event Selector";
        l4_evidence = "input/docs/ibex_cs_registers.rst";
        l4_extraction_strategy = "rst_grid_csr_v1_6_566";
        l4_reset_value_kind = "numeric";
        l4_reset_value_source = "scalar_prose_adjacency_v1_6_503";
        l4_access_literal = "WARL";
        field { sw = rw; reset = 32'h1; desc = "Machine Performance-Monitoring Event Selector"; l4_access_inherited = true; l4_synthesised_source = "summary_table_only"; l4_synthesised_whole_register_field = true; l4_access_literal = "WARL"; } WHOLE_REG[31:0];
    } mhpmevent31 @ 0x33F;
    reg {
        regwidth = 32;
        desc = "Machine Trap Value Register";
        l4_evidence = "input/docs/ibex_cs_registers.rst";
        l4_extraction_strategy = "rst_grid_csr_v1_6_566";
        l4_access_literal = "WARL";
        field { sw = rw; reset = 32'h0; desc = "Machine Trap Value Register"; l4_access_inherited = true; l4_synthesised_source = "summary_table_only"; l4_synthesised_whole_register_field = true; l4_access_literal = "WARL"; } WHOLE_REG[31:0];
    } mtval @ 0x343;
    reg {
        regwidth = 32;
        desc = "PMP Configuration Register";
        l4_evidence = "input/docs/ibex_cs_registers.rst";
        l4_extraction_strategy = "rst_grid_csr_v1_6_566";
        l4_access_literal = "WARL";
        field { sw = rw; desc = "PMP Configuration Register"; l4_access_inherited = true; l4_synthesised_source = "summary_table_only"; l4_synthesised_whole_register_field = true; l4_access_literal = "WARL"; } WHOLE_REG[31:0];
    } pmpcfg0 @ 0x3A0;
    reg {
        regwidth = 32;
        desc = "PMP Address Register";
        l4_evidence = "input/docs/ibex_cs_registers.rst";
        l4_extraction_strategy = "rst_grid_csr_v1_6_566";
        l4_access_literal = "WARL";
        field { sw = rw; desc = "PMP Address Register"; l4_access_inherited = true; l4_synthesised_source = "summary_table_only"; l4_synthesised_whole_register_field = true; l4_access_literal = "WARL"; } WHOLE_REG[31:0];
    } pmpaddr0 @ 0x3B0;
    reg {
        regwidth = 32;
        desc = "PMP Address Register";
        l4_evidence = "input/docs/ibex_cs_registers.rst";
        l4_extraction_strategy = "rst_grid_csr_v1_6_566";
        l4_access_literal = "WARL";
        field { sw = rw; desc = "PMP Address Register"; l4_access_inherited = true; l4_synthesised_source = "summary_table_only"; l4_synthesised_whole_register_field = true; l4_access_literal = "WARL"; } WHOLE_REG[31:0];
    } pmpaddr15 @ 0x3BF;
    reg {
        regwidth = 32;
        desc = "Supervisor Context Register";
        l4_evidence = "input/docs/ibex_cs_registers.rst";
        l4_extraction_strategy = "rst_grid_csr_v1_6_566";
        l4_access_literal = "WARL";
        field { sw = rw; desc = "Supervisor Context Register"; l4_access_inherited = true; l4_synthesised_source = "summary_table_only"; l4_synthesised_whole_register_field = true; l4_access_literal = "WARL"; } WHOLE_REG[31:0];
    } scontext @ 0x5A8;
    reg {
        regwidth = 8;
        desc = "Machine Security Configuration";
        l4_evidence = "input/docs/ibex_cs_registers.rst";
        l4_extraction_strategy = "rst_grid_csr_v1_6_566";
        l4_reset_value_kind = "numeric";
        l4_access_literal = "WARL";
        field { sw = rw; reset = 1'h0; desc = "**Rule Locking Bypass (RLB):** If set locked PMP entries can be modified"; l4_access_inherited = true; l4_extraction_strategy = "asciidoc_rowspan_fields_acronym_tier1_v1_6_377_via_rst_bitdef_2col_v1_6_412+inherited_v1_6_488"; l4_access_literal = "WARL"; } RLB[2:2];
        field { sw = rw; reset = 1'h0; desc = "**Machine Mode Whitelist Policy (MMWP):** If set default policy for PMP is deny for M-Mode accesses that don't match a PMP region"; l4_access_inherited = true; l4_extraction_strategy = "asciidoc_rowspan_fields_acronym_tier1_v1_6_377_via_rst_bitdef_2col_v1_6_412+inherited_v1_6_488"; l4_access_literal = "WARL"; } MMWP[1:1];
        field { sw = rw; reset = 1'h0; desc = "**Machine Mode Lockdown (MML):** Alters behaviour of ``pmpcfgX`` bits"; l4_access_inherited = true; l4_extraction_strategy = "asciidoc_rowspan_fields_acronym_tier1_v1_6_377_via_rst_bitdef_2col_v1_6_412+inherited_v1_6_488"; l4_access_literal = "WARL"; } MML[0:0];
    } mseccfg @ 0x747;
    reg {
        regwidth = 32;
        desc = "Upper 32 bits of ``mseccfg";
        l4_evidence = "input/docs/ibex_cs_registers.rst";
        l4_extraction_strategy = "rst_grid_csr_v1_6_566";
        l4_access_literal = "WARL";
        field { sw = rw; desc = "Upper 32 bits of ``mseccfg``"; l4_access_inherited = true; l4_synthesised_source = "summary_table_only"; l4_synthesised_whole_register_field = true; l4_access_literal = "WARL"; } WHOLE_REG[31:0];
    } mseccfgh @ 0x757;
    reg {
        regwidth = 32;
        desc = "Trigger Select Register";
        l4_evidence = "input/docs/ibex_cs_registers.rst";
        l4_extraction_strategy = "rst_grid_csr_v1_6_566";
        l4_access_literal = "WARL";
        field { sw = rw; reset = 32'h0; desc = "Trigger Select Register"; l4_access_inherited = true; l4_synthesised_source = "summary_table_only"; l4_synthesised_whole_register_field = true; l4_access_literal = "WARL"; } WHOLE_REG[31:0];
    } tselect @ 0x7A0;
    reg {
        regwidth = 32;
        desc = "Machine Context Register";
        l4_evidence = "input/docs/ibex_cs_registers.rst";
        l4_extraction_strategy = "rst_grid_csr_v1_6_566";
        l4_access_literal = "WARL";
        field { sw = rw; reset = 32'h0; desc = "Machine Context Register"; l4_access_inherited = true; l4_synthesised_source = "summary_table_only"; l4_synthesised_whole_register_field = true; l4_access_literal = "WARL"; } WHOLE_REG[31:0];
    } mcontext @ 0x7A8;
    reg {
        regwidth = 32;
        desc = "Debug Control and Status Register";
        l4_evidence = "input/docs/ibex_cs_registers.rst";
        l4_extraction_strategy = "rst_grid_csr_v1_6_566";
        l4_reset_value_kind = "numeric";
        l4_access_literal = "WARL";
        field { sw = r; reset = 4'h4; desc = "**xdebugver:** 4 = External spec-compliant debug support exists."; encode = dcsr_BITS_31_28_e; l4_extraction_strategy = "asciidoc_rowspan_fields_bits_fallback"; l4_access_literal = "R"; } BITS_31_28[31:28];
        field { sw = rw; reset = 1'h0; desc = "**ebreakm:** EBREAK in M-Mode behaves as described in Privileged"; l4_extraction_strategy = "asciidoc_rowspan_fields_bits_fallback"; l4_access_literal = "RW"; } BITS_15[15:15];
        field { sw = rw; reset = 1'h0; desc = "**ebreaku:** EBREAK in U-Mode behaves as described in Privileged"; l4_extraction_strategy = "asciidoc_rowspan_fields_bits_fallback"; l4_access_literal = "WARL"; } BITS_12[12:12];
        field { sw = r; reset = 3'h0; desc = "**cause:** 1 = EBREAK, 2 = trigger, 3 = halt request, 4 = step"; encode = dcsr_BITS_8_6_e; l4_extraction_strategy = "asciidoc_rowspan_fields_bits_fallback"; l4_access_literal = "R"; } BITS_8_6[8:6];
        field { sw = rw; reset = 1'h0; desc = "**step:** When set and not in Debug Mode, execute a single"; l4_extraction_strategy = "asciidoc_rowspan_fields_bits_fallback"; l4_access_literal = "RW"; } BITS_2[2:2];
        field { sw = rw; reset = 2'h3; desc = "**prv:** Privilege level the core was operating in when Debug"; l4_extraction_strategy = "asciidoc_rowspan_fields_bits_fallback"; l4_access_literal = "WARL"; } BITS_1_0[1:0];
    } dcsr @ 0x7B0;
    reg {
        regwidth = 16;
        desc = "CPU Control and Status Register (Custom CSR)";
        l4_evidence = "input/docs/ibex_cs_registers.rst";
        l4_extraction_strategy = "rst_grid_csr_v1_6_566";
        l4_reset_value_kind = "numeric";
        l4_access_literal = "WARL";
        field { sw = r; reset = 1'h0; desc = "**ic_scr_key_valid:** The icache scrambling key is valid. A"; l4_extraction_strategy = "asciidoc_rowspan_fields_bits_fallback"; l4_access_literal = "R"; } BITS_8[8:8];
        field { sw = rw; reset = 1'h0; desc = "**double_fault_seen:** A synchronous exception was observed when"; l4_extraction_strategy = "asciidoc_rowspan_fields_bits_fallback"; l4_access_literal = "RW"; } BITS_7[7:7];
        field { sw = rw; reset = 1'h0; desc = "**sync_exc_seen:** A synchronous exception has been observed."; l4_extraction_strategy = "asciidoc_rowspan_fields_bits_fallback"; l4_access_literal = "RW"; } BITS_6[6:6];
        field { sw = rw; reset = 3'h0; desc = "**dummy_instr_mask:** Mask to control frequency of dummy"; l4_extraction_strategy = "asciidoc_rowspan_fields_bits_fallback"; l4_access_literal = "WARL"; } BITS_5_3[5:3];
        field { sw = rw; reset = 1'h0; desc = "**dummy_instr_en:** Enable (1) or disable (0) dummy instruction"; l4_extraction_strategy = "asciidoc_rowspan_fields_bits_fallback"; l4_access_literal = "WARL"; } BITS_2[2:2];
        field { sw = rw; reset = 1'h0; desc = "**data_ind_timing:** Enable (1) or disable (0) data-independent"; l4_extraction_strategy = "asciidoc_rowspan_fields_bits_fallback"; l4_access_literal = "WARL"; } BITS_1[1:1];
        field { sw = rw; reset = 1'h0; desc = "**icache_enable:** Enable (1) or disable (0) the instruction"; l4_extraction_strategy = "asciidoc_rowspan_fields_bits_fallback"; l4_access_literal = "WARL"; } BITS_0[0:0];
    } cpuctrlsts @ 0x7C0;
    reg {
        regwidth = 32;
        desc = "Machine Cycle Counter";
        l4_evidence = "input/docs/ibex_cs_registers.rst";
        l4_extraction_strategy = "rst_grid_csr_v1_6_566";
        l4_is_counter = true;
        l4_reset_value_kind = "numeric";
        l4_reset_value_source = "scalar_prose_broader_v1_6_505";
        l4_access_literal = "RW";
        field { sw = rw; reset = 32'h28; desc = "Machine Cycle Counter"; l4_access_inherited = true; l4_synthesised_source = "summary_table_only"; l4_synthesised_whole_register_field = true; l4_access_literal = "RW"; } WHOLE_REG[31:0];
    } mcycle @ 0xB00;
    reg {
        regwidth = 32;
        desc = "Machine Performance-Monitoring Counter";
        l4_evidence = "input/docs/ibex_cs_registers.rst";
        l4_extraction_strategy = "rst_grid_csr_v1_6_566";
        l4_is_counter = true;
        l4_reset_value_kind = "numeric";
        l4_reset_value_source = "scalar_prose_adjacency_v1_6_503";
        l4_access_literal = "WARL";
        field { sw = rw; reset = 32'h1; desc = "Machine Performance-Monitoring Counter"; l4_access_inherited = true; l4_synthesised_source = "summary_table_only"; l4_synthesised_whole_register_field = true; l4_access_literal = "WARL"; } WHOLE_REG[31:0];
    } mhpmcounter31 @ 0xB1F;
    reg {
        regwidth = 32;
        desc = "Upper 32 bits of ``mcycle";
        l4_evidence = "input/docs/ibex_cs_registers.rst";
        l4_extraction_strategy = "rst_grid_csr_v1_6_566";
        l4_is_counter = true;
        l4_access_literal = "RW";
        field { sw = rw; desc = "Upper 32 bits of ``mcycle``"; l4_access_inherited = true; l4_synthesised_source = "summary_table_only"; l4_synthesised_whole_register_field = true; l4_access_literal = "RW"; } WHOLE_REG[31:0];
    } mcycleh @ 0xB80;
    reg {
        regwidth = 32;
        desc = "Upper 32 bits of ``mhmpcounter31";
        l4_evidence = "input/docs/ibex_cs_registers.rst";
        l4_extraction_strategy = "rst_grid_csr_v1_6_566";
        l4_is_counter = true;
        l4_access_literal = "WARL";
        field { sw = rw; desc = "Upper 32 bits of ``mhmpcounter31``"; l4_access_inherited = true; l4_synthesised_source = "summary_table_only"; l4_synthesised_whole_register_field = true; l4_access_literal = "WARL"; } WHOLE_REG[31:0];
    } mhpmcounter31h @ 0xB9F;
    reg {
        regwidth = 32;
        desc = "reset=0x0000_0000";
        l4_evidence = "input/docs/ibex_cs_registers.rst";
        l4_access_literal = "R/W";
        field { sw = rw; reset = 32'h0; desc = "reset=0x0000_0000"; l4_access_inherited = true; l4_synthesised_source = "summary_table_only"; l4_synthesised_whole_register_field = true; l4_access_literal = "R/W"; } WHOLE_REG[31:0];
    } csr_f11 @ 0xF11;
};
