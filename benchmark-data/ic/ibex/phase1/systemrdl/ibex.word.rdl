// SystemRDL 2.0 — generated by l4_systemrdl_export.py (vibe-ic#377 B).
// SOURCE: benchmark-data/ic/ibex/phase1/generated_docs/L4_REGMAP.json
//
// THIS FILE IS NOT A COMPLETE DESCRIPTION OF THE SOURCE REGISTER MAP.
//     30 L4 statements had NO SystemRDL construct and are absent here
//    277 landed WEAKER, STRONGER or DIFFERENT than the source said
//    236 are carried only through user-defined properties
// Every one is named, with a reason, in the companion ledger JSON.
// Reading this file without the ledger will overstate what is known.
//
// address unit: word (CALLER ASSERTION — L4 states no unit)

property l4_purpose { type = string; component = reg; };
property l4_structure_summary { type = string; component = reg; };
property l4_sub_address_hex { type = string; component = reg; };
property l4_reset_value_kind { type = string; component = reg; };
property l4_reset_value_source { type = string; component = reg; };
property l4_is_counter { type = boolean; component = reg; };
property l4_kind { type = string; component = reg; };
property l4_endpoint { type = string; component = reg; };
property l4_range { type = string; component = reg; };
property l4_low_confidence { type = boolean; component = reg; };
property l4_role { type = string; component = reg; };
property l4_scope { type = string; component = reg; };
property l4_ap_or_dp { type = string; component = reg; };
property l4_regad { type = string; component = reg; };
property l4_dlab { type = string; component = reg; };
property l4_capture_value { type = string; component = reg; };
property l4_compute_rule { type = string; component = reg; };
property l4_common_values_hex { type = string; component = reg; };
property l4_common_values_hex_lsb_first { type = string; component = reg; };
property l4_evidence { type = string; component = reg | field; };
property l4_evidence_line { type = string; component = reg | field; };
property l4_extraction_strategy { type = string; component = reg | field; };
property l4_access_literal { type = string; component = reg | field; };
property l4_access_inherited { type = boolean; component = field; };
property l4_synthesised_whole_register_field { type = boolean; component = field; };
property l4_synthesised_source { type = string; component = field; };
property l4_feature_address { type = string; component = field; };

enum tdata1_BITS_31_28_e {
    Address = 4'b0010 { desc = "Address"; };
    Only = 4'b0001 { desc = "Only"; };
    Only_0000 = 4'b0000 { desc = "Only"; };
};
enum tdata1_BITS_26_21_e {
    Address = 6'b000010 { desc = "Address"; };
    Only = 6'b000001 { desc = "Only"; };
    Only_000000 = 6'b000000 { desc = "Only"; };
};
enum tdata1_BITS_17_16_e {
    Address = 2'b10 { desc = "Address"; };
    Only = 2'b01 { desc = "Only"; };
    Only_00 = 2'b00 { desc = "Only"; };
};
enum tdata1_BITS_15_12_e {
    Address = 4'b0010 { desc = "Address"; };
    Only = 4'b0001 { desc = "Only"; };
    Only_0000 = 4'b0000 { desc = "Only"; };
};
enum tdata1_BITS_10_7_e {
    Address = 4'b0010 { desc = "Address"; };
    Only = 4'b0001 { desc = "Only"; };
    Only_0000 = 4'b0000 { desc = "Only"; };
};
enum dcsr_BITS_31_28_e {
    External_ = 4'b0100 { desc = "External"; };
};
enum dcsr_BITS_8_6_e {
    External_ = 3'b100 { desc = "External"; };
};

addrmap ibex {
    desc = "Module memory map per spec. Reads from reserved bits return zeros and writes to reserved bits have no effect.";
    reg {
        regwidth = 32;
        desc = "Machine Status";
        l4_evidence = "input/docs/ibex_cs_registers.rst";
        l4_extraction_strategy = "rst_grid_csr_v1_6_566";
        l4_reset_value_kind = "numeric";
        l4_access_literal = "WARL";
        field { sw = rw; reset = 1'h0; desc = "Timeout Wait (WFI executed in User Mode will trap to Machine Mode)."; l4_access_literal = "RW"; } TW[21:21];
        field { sw = rw; reset = 1'h0; desc = "Modify Privilege (Loads and stores use MPP for privilege checking)."; l4_access_literal = "RW"; } MPRV[17:17];
        field { sw = rw; reset = 2'h0; desc = "Machine Previous Privilege mode."; l4_access_literal = "RW"; } MPP[12:11];
        field { sw = rw; reset = 1'h1; desc = "**Previous Interrupt Enable (MPIE)**, i.e., before entering exception handling."; l4_extraction_strategy = "asciidoc_rowspan_fields_acronym_tier0_v1_6_377_via_rst_bitfield_v1_6_408"; l4_access_literal = "RW"; } MPIE[7:7];
        field { sw = rw; reset = 1'h0; desc = "**Interrupt Enable (MIE):** If set to 1'b1, interrupts are globally enabled."; l4_extraction_strategy = "asciidoc_rowspan_fields_acronym_tier1_v1_6_377_via_rst_bitfield_v1_6_408"; l4_access_literal = "RW"; } MIE[3:3];
    } mstatus @ 0xC00;
    reg {
        regwidth = 32;
        desc = "Machine ISA and Extensions";
        l4_evidence = "input/docs/ibex_cs_registers.rst";
        l4_extraction_strategy = "rst_grid_csr_v1_6_566";
        l4_reset_value_kind = "symbolic";
        l4_access_literal = "WARL";
        field { sw = rw; desc = "Machine ISA and Extensions"; l4_access_inherited = true; l4_synthesised_source = "summary_table_only"; l4_synthesised_whole_register_field = true; l4_access_literal = "WARL"; } WHOLE_REG[31:0];
    } misa @ 0xC04;
    reg {
        regwidth = 32;
        desc = "Machine Interrupt Enable Register";
        l4_evidence = "input/docs/ibex_cs_registers.rst";
        l4_extraction_strategy = "rst_grid_csr_v1_6_566";
        l4_reset_value_kind = "numeric";
        l4_access_literal = "WARL";
        field { sw = rw; reset = 15'h0; desc = "Machine Fast Interrupt Enables: Set bit x+16 to enable"; l4_access_inherited = true; l4_extraction_strategy = "asciidoc_rowspan_fields_bits_fallback"; l4_access_literal = "WARL"; } BITS_30_16[30:16];
        field { sw = rw; reset = 1'h0; desc = "If set, ``irq_external_i`` is enabled."; l4_access_inherited = true; l4_access_literal = "WARL"; } MEIE[11:11];
        field { sw = rw; reset = 1'h0; desc = "If set, ``irq_timer_i`` is enabled."; l4_access_inherited = true; l4_access_literal = "WARL"; } MTIE[7:7];
        field { sw = rw; reset = 1'h0; desc = "if set, ``irq_software_i`` is enabled."; l4_access_inherited = true; l4_access_literal = "WARL"; } MSIE[3:3];
    } mie @ 0xC10;
    reg {
        regwidth = 32;
        desc = "Machine Trap-Vector Base Address";
        l4_evidence = "input/docs/ibex_cs_registers.rst";
        l4_extraction_strategy = "rst_grid_csr_v1_6_566";
        l4_reset_value_kind = "numeric";
        l4_access_literal = "WARL";
        field { sw = rw; reset = 30'h0; desc = "The trap-vector base address, always aligned to 256 bytes, i.e.,"; l4_access_inherited = true; l4_extraction_strategy = "inherited_v1_6_488"; l4_access_literal = "WARL"; } BASE[31:2];
        field { sw = rw; reset = 2'h1; desc = "Always set to 2'b01 to indicate vectored interrupt handling (read-only)."; l4_access_inherited = true; l4_extraction_strategy = "inherited_v1_6_488"; l4_access_literal = "WARL"; } MODE[1:0];
    } mtvec @ 0xC14;
    reg {
        regwidth = 32;
        desc = "Machine Counter-Inhibit Register";
        l4_evidence = "input/docs/ibex_cs_registers.rst";
        l4_extraction_strategy = "rst_grid_csr_v1_6_566";
        l4_is_counter = true;
        l4_access_literal = "RW";
        field { sw = rw; desc = "Machine Counter-Inhibit Register"; l4_access_inherited = true; l4_synthesised_source = "summary_table_only"; l4_synthesised_whole_register_field = true; l4_access_literal = "RW"; } WHOLE_REG[31:0];
    } mcountinhibit @ 0xC80;
    reg {
        regwidth = 32;
        desc = "Machine Performance-Monitoring Event Selector";
        l4_evidence = "input/docs/ibex_cs_registers.rst";
        l4_extraction_strategy = "rst_grid_csr_v1_6_566";
        l4_reset_value_kind = "numeric";
        l4_reset_value_source = "scalar_prose_adjacency_v1_6_503";
        l4_access_literal = "WARL";
        field { sw = rw; reset = 32'h1; desc = "Machine Performance-Monitoring Event Selector"; l4_access_inherited = true; l4_synthesised_source = "summary_table_only"; l4_synthesised_whole_register_field = true; l4_access_literal = "WARL"; } WHOLE_REG[31:0];
    } mhpmevent3 @ 0xC8C;
    reg {
        regwidth = 32;
        desc = "Machine Performance-Monitoring Event Selector";
        l4_evidence = "input/docs/ibex_cs_registers.rst";
        l4_extraction_strategy = "rst_grid_csr_v1_6_566";
        l4_reset_value_kind = "numeric";
        l4_reset_value_source = "scalar_prose_adjacency_v1_6_503";
        l4_access_literal = "WARL";
        field { sw = rw; reset = 32'h1; desc = "Machine Performance-Monitoring Event Selector"; l4_access_inherited = true; l4_synthesised_source = "summary_table_only"; l4_synthesised_whole_register_field = true; l4_access_literal = "WARL"; } WHOLE_REG[31:0];
    } mhpmevent31 @ 0xCFC;
    reg {
        regwidth = 32;
        desc = "Machine Scratch Register";
        l4_evidence = "input/docs/ibex_cs_registers.rst";
        l4_extraction_strategy = "rst_grid_csr_v1_6_566";
        l4_access_literal = "RW";
        field { sw = rw; desc = "Machine Scratch Register"; l4_access_inherited = true; l4_synthesised_source = "summary_table_only"; l4_synthesised_whole_register_field = true; l4_access_literal = "RW"; } WHOLE_REG[31:0];
    } mscratch @ 0xD00;
    reg {
        regwidth = 32;
        desc = "Machine Exception Program Counter";
        l4_evidence = "input/docs/ibex_cs_registers.rst";
        l4_extraction_strategy = "rst_grid_csr_v1_6_566";
        l4_is_counter = true;
        l4_access_literal = "WARL";
        field { sw = rw; reset = 32'h0; desc = "Machine Exception Program Counter"; l4_access_inherited = true; l4_synthesised_source = "summary_table_only"; l4_synthesised_whole_register_field = true; l4_access_literal = "WARL"; } WHOLE_REG[31:0];
    } mepc @ 0xD04;
    reg {
        regwidth = 32;
        desc = "Machine Cause Register";
        l4_evidence = "input/docs/ibex_cs_registers.rst";
        l4_extraction_strategy = "rst_grid_csr_v1_6_566";
        l4_reset_value_kind = "numeric";
        l4_access_literal = "WLRL";
        field { sw = r; reset = 1'h0; desc = "**Interrupt:** This bit is set when the exception was triggered"; l4_extraction_strategy = "asciidoc_rowspan_fields_bits_fallback"; l4_access_literal = "R"; } BITS_31[31:31];
        field { sw = r; reset = 5'h0; desc = "**Exception Code**"; l4_extraction_strategy = "asciidoc_rowspan_fields_bits_fallback"; l4_access_literal = "R"; } BITS_4_0[4:0];
    } mcause @ 0xD08;
    reg {
        regwidth = 32;
        desc = "Machine Trap Value Register";
        l4_evidence = "input/docs/ibex_cs_registers.rst";
        l4_extraction_strategy = "rst_grid_csr_v1_6_566";
        l4_access_literal = "WARL";
        field { sw = rw; reset = 32'h0; desc = "Machine Trap Value Register"; l4_access_inherited = true; l4_synthesised_source = "summary_table_only"; l4_synthesised_whole_register_field = true; l4_access_literal = "WARL"; } WHOLE_REG[31:0];
    } mtval @ 0xD0C;
    reg {
        regwidth = 32;
        desc = "PMP Configuration Register";
        l4_evidence = "input/docs/ibex_cs_registers.rst";
        l4_extraction_strategy = "rst_grid_csr_v1_6_566";
        l4_access_literal = "WARL";
        field { sw = rw; desc = "PMP Configuration Register"; l4_access_inherited = true; l4_synthesised_source = "summary_table_only"; l4_synthesised_whole_register_field = true; l4_access_literal = "WARL"; } WHOLE_REG[31:0];
    } pmpcfg0 @ 0xE80;
    reg {
        regwidth = 32;
        desc = "PMP Configuration Register";
        l4_evidence = "input/docs/ibex_cs_registers.rst";
        l4_extraction_strategy = "rst_grid_csr_v1_6_566";
        l4_access_literal = "WARL";
        field { sw = rw; desc = "PMP Configuration Register"; l4_access_inherited = true; l4_synthesised_source = "summary_table_only"; l4_synthesised_whole_register_field = true; l4_access_literal = "WARL"; } WHOLE_REG[31:0];
    } pmpcfg3 @ 0xE8C;
    reg {
        regwidth = 32;
        desc = "PMP Address Register";
        l4_evidence = "input/docs/ibex_cs_registers.rst";
        l4_extraction_strategy = "rst_grid_csr_v1_6_566";
        l4_access_literal = "WARL";
        field { sw = rw; desc = "PMP Address Register"; l4_access_inherited = true; l4_synthesised_source = "summary_table_only"; l4_synthesised_whole_register_field = true; l4_access_literal = "WARL"; } WHOLE_REG[31:0];
    } pmpaddr0 @ 0xEC0;
    reg {
        regwidth = 32;
        desc = "PMP Address Register";
        l4_evidence = "input/docs/ibex_cs_registers.rst";
        l4_extraction_strategy = "rst_grid_csr_v1_6_566";
        l4_access_literal = "WARL";
        field { sw = rw; desc = "PMP Address Register"; l4_access_inherited = true; l4_synthesised_source = "summary_table_only"; l4_synthesised_whole_register_field = true; l4_access_literal = "WARL"; } WHOLE_REG[31:0];
    } pmpaddr15 @ 0xEFC;
    reg {
        regwidth = 32;
        desc = "Supervisor Context Register";
        l4_evidence = "input/docs/ibex_cs_registers.rst";
        l4_extraction_strategy = "rst_grid_csr_v1_6_566";
        l4_access_literal = "WARL";
        field { sw = rw; desc = "Supervisor Context Register"; l4_access_inherited = true; l4_synthesised_source = "summary_table_only"; l4_synthesised_whole_register_field = true; l4_access_literal = "WARL"; } WHOLE_REG[31:0];
    } scontext @ 0x16A0;
    reg {
        regwidth = 8;
        desc = "Machine Security Configuration";
        l4_evidence = "input/docs/ibex_cs_registers.rst";
        l4_extraction_strategy = "rst_grid_csr_v1_6_566";
        l4_reset_value_kind = "numeric";
        l4_access_literal = "WARL";
        field { sw = rw; reset = 1'h0; desc = "**Rule Locking Bypass (RLB):** If set locked PMP entries can be modified"; l4_access_inherited = true; l4_extraction_strategy = "asciidoc_rowspan_fields_acronym_tier1_v1_6_377_via_rst_bitdef_2col_v1_6_412+inherited_v1_6_488"; l4_access_literal = "WARL"; } RLB[2:2];
        field { sw = rw; reset = 1'h0; desc = "**Machine Mode Whitelist Policy (MMWP):** If set default policy for PMP is deny for M-Mode accesses that don't match a PMP region"; l4_access_inherited = true; l4_extraction_strategy = "asciidoc_rowspan_fields_acronym_tier1_v1_6_377_via_rst_bitdef_2col_v1_6_412+inherited_v1_6_488"; l4_access_literal = "WARL"; } MMWP[1:1];
        field { sw = rw; reset = 1'h0; desc = "**Machine Mode Lockdown (MML):** Alters behaviour of ``pmpcfgX`` bits"; l4_access_inherited = true; l4_extraction_strategy = "asciidoc_rowspan_fields_acronym_tier1_v1_6_377_via_rst_bitdef_2col_v1_6_412+inherited_v1_6_488"; l4_access_literal = "WARL"; } MML[0:0];
    } mseccfg @ 0x747;
    reg {
        regwidth = 32;
        desc = "Upper 32 bits of ``mseccfg";
        l4_evidence = "input/docs/ibex_cs_registers.rst";
        l4_extraction_strategy = "rst_grid_csr_v1_6_566";
        l4_access_literal = "WARL";
        field { sw = rw; desc = "Upper 32 bits of ``mseccfg``"; l4_access_inherited = true; l4_synthesised_source = "summary_table_only"; l4_synthesised_whole_register_field = true; l4_access_literal = "WARL"; } WHOLE_REG[31:0];
    } mseccfgh @ 0x1D5C;
    reg {
        regwidth = 32;
        desc = "Trigger Select Register";
        l4_evidence = "input/docs/ibex_cs_registers.rst";
        l4_extraction_strategy = "rst_grid_csr_v1_6_566";
        l4_access_literal = "WARL";
        field { sw = rw; reset = 32'h0; desc = "Trigger Select Register"; l4_access_inherited = true; l4_synthesised_source = "summary_table_only"; l4_synthesised_whole_register_field = true; l4_access_literal = "WARL"; } WHOLE_REG[31:0];
    } tselect @ 0x1E80;
    reg {
        regwidth = 32;
        desc = "Trigger Data Register 1";
        l4_evidence = "input/docs/ibex_cs_registers.rst";
        l4_extraction_strategy = "rst_grid_csr_v1_6_566";
        l4_reset_value_kind = "numeric";
        l4_access_literal = "WARL";
        field { sw = r; reset = 4'h2; desc = "**type:** 2 = Address/Data match trigger type."; encode = tdata1_BITS_31_28_e; l4_extraction_strategy = "asciidoc_rowspan_fields_bits_fallback"; l4_access_literal = "R"; } BITS_31_28[31:28];
        field { sw = r; reset = 1'h1; desc = "**dmode:** 1 = Only debug mode can write tdata registers"; l4_extraction_strategy = "asciidoc_rowspan_fields_bits_fallback"; l4_access_literal = "R"; } BITS_27[27:27];
        field { sw = r; reset = 6'h0; desc = "**maskmax:** 0 = Only exact matching supported."; encode = tdata1_BITS_26_21_e; l4_extraction_strategy = "asciidoc_rowspan_fields_bits_fallback"; l4_access_literal = "R"; } BITS_26_21[26:21];
        field { sw = r; reset = 1'h0; desc = "**hit:** 0 = Hit indication not supported."; l4_extraction_strategy = "asciidoc_rowspan_fields_bits_fallback"; l4_access_literal = "R"; } BITS_20[20:20];
        field { sw = r; reset = 1'h0; desc = "**select:** 0 = Only address matching is supported."; l4_extraction_strategy = "asciidoc_rowspan_fields_bits_fallback"; l4_access_literal = "R"; } BITS_19[19:19];
        field { sw = r; reset = 1'h0; desc = "**timing:** 0 = Break before the instruction at the specified"; l4_extraction_strategy = "asciidoc_rowspan_fields_bits_fallback"; l4_access_literal = "R"; } BITS_18[18:18];
        field { sw = r; reset = 2'h0; desc = "**sizelo:** 0 = Match accesses of any size."; encode = tdata1_BITS_17_16_e; l4_extraction_strategy = "asciidoc_rowspan_fields_bits_fallback"; l4_access_literal = "R"; } BITS_17_16[17:16];
        field { sw = r; reset = 4'h1; desc = "**action:** 1 = Enter debug mode on match."; encode = tdata1_BITS_15_12_e; l4_extraction_strategy = "asciidoc_rowspan_fields_bits_fallback"; l4_access_literal = "R"; } BITS_15_12[15:12];
        field { sw = r; reset = 1'h0; desc = "**chain:** 0 = Chaining not supported."; l4_extraction_strategy = "asciidoc_rowspan_fields_bits_fallback"; l4_access_literal = "R"; } BITS_11[11:11];
        field { sw = r; reset = 4'h0; desc = "**match:** 0 = Match the whole address."; encode = tdata1_BITS_10_7_e; l4_extraction_strategy = "asciidoc_rowspan_fields_bits_fallback"; l4_access_literal = "R"; } BITS_10_7[10:7];
        field { sw = r; reset = 1'h0; desc = "**m:** 1 = Match in M-Mode."; l4_extraction_strategy = "asciidoc_rowspan_fields_bits_fallback"; l4_access_literal = "R"; } BITS_6[6:6];
        field { sw = r; reset = 1'h0; desc = "zero."; l4_extraction_strategy = "asciidoc_rowspan_fields_bits_fallback"; l4_access_literal = "R"; } BITS_5[5:5];
        field { sw = r; reset = 1'h0; desc = "**s:** 0 = S-Mode not supported."; l4_extraction_strategy = "asciidoc_rowspan_fields_bits_fallback"; l4_access_literal = "R"; } BITS_4[4:4];
        field { sw = r; reset = 1'h0; desc = "**u:** 1 = Match in U-Mode."; l4_extraction_strategy = "asciidoc_rowspan_fields_bits_fallback"; l4_access_literal = "R"; } BITS_3[3:3];
        field { sw = rw; reset = 1'h0; desc = "**execute:** Enable matching on instruction address."; l4_extraction_strategy = "asciidoc_rowspan_fields_bits_fallback"; l4_access_literal = "RW"; } BITS_2[2:2];
        field { sw = r; reset = 1'h0; desc = "**store:** 0 = Store address / data matching not supported."; l4_extraction_strategy = "asciidoc_rowspan_fields_bits_fallback"; l4_access_literal = "R"; } BITS_1[1:1];
        field { sw = r; reset = 1'h0; desc = "**load:** 0 = Load address / data matching not supported."; l4_extraction_strategy = "asciidoc_rowspan_fields_bits_fallback"; l4_access_literal = "R"; } BITS_0[0:0];
    } tdata1 @ 0x1E84;
    reg {
        regwidth = 32;
        desc = "Trigger Data Register 2";
        l4_evidence = "input/docs/ibex_cs_registers.rst";
        l4_extraction_strategy = "rst_grid_csr_v1_6_566";
        l4_access_literal = "WARL";
        field { sw = rw; reset = 32'h0; desc = "Trigger Data Register 2"; l4_access_inherited = true; l4_synthesised_source = "summary_table_only"; l4_synthesised_whole_register_field = true; l4_access_literal = "WARL"; } WHOLE_REG[31:0];
    } tdata2 @ 0x1E88;
    reg {
        regwidth = 32;
        desc = "Trigger Data Register 3";
        l4_evidence = "input/docs/ibex_cs_registers.rst";
        l4_extraction_strategy = "rst_grid_csr_v1_6_566";
        l4_access_literal = "WARL";
        field { sw = rw; reset = 32'h0; desc = "Trigger Data Register 3"; l4_access_inherited = true; l4_synthesised_source = "summary_table_only"; l4_synthesised_whole_register_field = true; l4_access_literal = "WARL"; } WHOLE_REG[31:0];
    } tdata3 @ 0x1E8C;
    reg {
        regwidth = 32;
        desc = "Machine Context Register";
        l4_evidence = "input/docs/ibex_cs_registers.rst";
        l4_extraction_strategy = "rst_grid_csr_v1_6_566";
        l4_access_literal = "WARL";
        field { sw = rw; reset = 32'h0; desc = "Machine Context Register"; l4_access_inherited = true; l4_synthesised_source = "summary_table_only"; l4_synthesised_whole_register_field = true; l4_access_literal = "WARL"; } WHOLE_REG[31:0];
    } mcontext @ 0x1EA0;
    reg {
        regwidth = 32;
        desc = "Machine Supervisor Context Register";
        l4_evidence = "input/docs/ibex_cs_registers.rst";
        l4_extraction_strategy = "rst_grid_csr_v1_6_566";
        l4_access_literal = "WARL";
        field { sw = rw; reset = 32'h0; desc = "Machine Supervisor Context Register"; l4_access_inherited = true; l4_synthesised_source = "summary_table_only"; l4_synthesised_whole_register_field = true; l4_access_literal = "WARL"; } WHOLE_REG[31:0];
    } mscontext @ 0x1EA8;
    reg {
        regwidth = 32;
        desc = "Debug Control and Status Register";
        l4_evidence = "input/docs/ibex_cs_registers.rst";
        l4_extraction_strategy = "rst_grid_csr_v1_6_566";
        l4_reset_value_kind = "numeric";
        l4_access_literal = "WARL";
        field { sw = r; reset = 4'h4; desc = "**xdebugver:** 4 = External spec-compliant debug support exists."; encode = dcsr_BITS_31_28_e; l4_extraction_strategy = "asciidoc_rowspan_fields_bits_fallback"; l4_access_literal = "R"; } BITS_31_28[31:28];
        field { sw = rw; reset = 1'h0; desc = "**ebreakm:** EBREAK in M-Mode behaves as described in Privileged"; l4_extraction_strategy = "asciidoc_rowspan_fields_bits_fallback"; l4_access_literal = "RW"; } BITS_15[15:15];
        field { sw = rw; reset = 1'h0; desc = "**ebreaku:** EBREAK in U-Mode behaves as described in Privileged"; l4_extraction_strategy = "asciidoc_rowspan_fields_bits_fallback"; l4_access_literal = "WARL"; } BITS_12[12:12];
        field { sw = r; reset = 3'h0; desc = "**cause:** 1 = EBREAK, 2 = trigger, 3 = halt request, 4 = step"; encode = dcsr_BITS_8_6_e; l4_extraction_strategy = "asciidoc_rowspan_fields_bits_fallback"; l4_access_literal = "R"; } BITS_8_6[8:6];
        field { sw = rw; reset = 1'h0; desc = "**step:** When set and not in Debug Mode, execute a single"; l4_extraction_strategy = "asciidoc_rowspan_fields_bits_fallback"; l4_access_literal = "RW"; } BITS_2[2:2];
        field { sw = rw; reset = 2'h3; desc = "**prv:** Privilege level the core was operating in when Debug"; l4_extraction_strategy = "asciidoc_rowspan_fields_bits_fallback"; l4_access_literal = "WARL"; } BITS_1_0[1:0];
    } dcsr @ 0x1EC0;
    reg {
        regwidth = 32;
        desc = "Debug PC";
        l4_evidence = "input/docs/ibex_cs_registers.rst";
        l4_extraction_strategy = "rst_grid_csr_v1_6_566";
        l4_access_literal = "RW";
        field { sw = rw; reset = 32'h0; desc = "Debug PC"; l4_access_inherited = true; l4_synthesised_source = "summary_table_only"; l4_synthesised_whole_register_field = true; l4_access_literal = "RW"; } WHOLE_REG[31:0];
    } dpc @ 0x1EC4;
    reg {
        regwidth = 32;
        desc = "Debug Scratch Register 0";
        l4_evidence = "input/docs/ibex_cs_registers.rst";
        l4_extraction_strategy = "rst_grid_csr_v1_6_566";
        l4_access_literal = "RW";
        field { sw = rw; reset = 32'h0; desc = "Debug Scratch Register 0"; l4_access_inherited = true; l4_synthesised_source = "summary_table_only"; l4_synthesised_whole_register_field = true; l4_access_literal = "RW"; } WHOLE_REG[31:0];
    } dscratch0 @ 0x1EC8;
    reg {
        regwidth = 32;
        desc = "Debug Scratch Register 1";
        l4_evidence = "input/docs/ibex_cs_registers.rst";
        l4_extraction_strategy = "rst_grid_csr_v1_6_566";
        l4_access_literal = "RW";
        field { sw = rw; reset = 32'h0; desc = "Debug Scratch Register 1"; l4_access_inherited = true; l4_synthesised_source = "summary_table_only"; l4_synthesised_whole_register_field = true; l4_access_literal = "RW"; } WHOLE_REG[31:0];
    } dscratch1 @ 0x1ECC;
    reg {
        regwidth = 16;
        desc = "CPU Control and Status Register (Custom CSR)";
        l4_evidence = "input/docs/ibex_cs_registers.rst";
        l4_extraction_strategy = "rst_grid_csr_v1_6_566";
        l4_reset_value_kind = "numeric";
        l4_access_literal = "WARL";
        field { sw = r; reset = 1'h0; desc = "**ic_scr_key_valid:** The icache scrambling key is valid. A"; l4_extraction_strategy = "asciidoc_rowspan_fields_bits_fallback"; l4_access_literal = "R"; } BITS_8[8:8];
        field { sw = rw; reset = 1'h0; desc = "**double_fault_seen:** A synchronous exception was observed when"; l4_extraction_strategy = "asciidoc_rowspan_fields_bits_fallback"; l4_access_literal = "RW"; } BITS_7[7:7];
        field { sw = rw; reset = 1'h0; desc = "**sync_exc_seen:** A synchronous exception has been observed."; l4_extraction_strategy = "asciidoc_rowspan_fields_bits_fallback"; l4_access_literal = "RW"; } BITS_6[6:6];
        field { sw = rw; reset = 3'h0; desc = "**dummy_instr_mask:** Mask to control frequency of dummy"; l4_extraction_strategy = "asciidoc_rowspan_fields_bits_fallback"; l4_access_literal = "WARL"; } BITS_5_3[5:3];
        field { sw = rw; reset = 1'h0; desc = "**dummy_instr_en:** Enable (1) or disable (0) dummy instruction"; l4_extraction_strategy = "asciidoc_rowspan_fields_bits_fallback"; l4_access_literal = "WARL"; } BITS_2[2:2];
        field { sw = rw; reset = 1'h0; desc = "**data_ind_timing:** Enable (1) or disable (0) data-independent"; l4_extraction_strategy = "asciidoc_rowspan_fields_bits_fallback"; l4_access_literal = "WARL"; } BITS_1[1:1];
        field { sw = rw; reset = 1'h0; desc = "**icache_enable:** Enable (1) or disable (0) the instruction"; l4_extraction_strategy = "asciidoc_rowspan_fields_bits_fallback"; l4_access_literal = "WARL"; } BITS_0[0:0];
    } cpuctrlsts @ 0xF80;
    reg {
        regwidth = 32;
        desc = "Security feature random seed (Custom CSR)";
        l4_evidence = "input/docs/ibex_cs_registers.rst";
        l4_extraction_strategy = "rst_grid_csr_v1_6_566";
        l4_access_literal = "WARL";
        field { sw = rw; reset = 32'h0; desc = "Security feature random seed (Custom CSR)"; l4_access_inherited = true; l4_synthesised_source = "summary_table_only"; l4_synthesised_whole_register_field = true; l4_access_literal = "WARL"; } WHOLE_REG[31:0];
    } secureseed @ 0x1F04;
    reg {
        regwidth = 32;
        desc = "Machine Cycle Counter";
        l4_evidence = "input/docs/ibex_cs_registers.rst";
        l4_extraction_strategy = "rst_grid_csr_v1_6_566";
        l4_is_counter = true;
        l4_reset_value_kind = "numeric";
        l4_reset_value_source = "scalar_prose_broader_v1_6_505";
        l4_access_literal = "RW";
        field { sw = rw; reset = 32'h28; desc = "Machine Cycle Counter"; l4_access_inherited = true; l4_synthesised_source = "summary_table_only"; l4_synthesised_whole_register_field = true; l4_access_literal = "RW"; } WHOLE_REG[31:0];
    } mcycle @ 0x2C00;
    reg {
        regwidth = 32;
        desc = "Machine Instructions-Retired Counter";
        l4_evidence = "input/docs/ibex_cs_registers.rst";
        l4_extraction_strategy = "rst_grid_csr_v1_6_566";
        l4_is_counter = true;
        l4_reset_value_kind = "numeric";
        l4_reset_value_source = "scalar_prose_broader_v1_6_505";
        l4_access_literal = "RW";
        field { sw = rw; reset = 32'h28; desc = "Machine Instructions-Retired Counter"; l4_access_inherited = true; l4_synthesised_source = "summary_table_only"; l4_synthesised_whole_register_field = true; l4_access_literal = "RW"; } WHOLE_REG[31:0];
    } minstret @ 0x2C08;
    reg {
        regwidth = 32;
        desc = "Machine Performance-Monitoring Counter";
        l4_evidence = "input/docs/ibex_cs_registers.rst";
        l4_extraction_strategy = "rst_grid_csr_v1_6_566";
        l4_is_counter = true;
        l4_reset_value_kind = "numeric";
        l4_reset_value_source = "scalar_prose_adjacency_v1_6_503";
        l4_access_literal = "WARL";
        field { sw = rw; reset = 32'h1; desc = "Machine Performance-Monitoring Counter"; l4_access_inherited = true; l4_synthesised_source = "summary_table_only"; l4_synthesised_whole_register_field = true; l4_access_literal = "WARL"; } WHOLE_REG[31:0];
    } mhpmcounter3 @ 0x2C0C;
    reg {
        regwidth = 32;
        desc = "Machine Performance-Monitoring Counter";
        l4_evidence = "input/docs/ibex_cs_registers.rst";
        l4_extraction_strategy = "rst_grid_csr_v1_6_566";
        l4_is_counter = true;
        l4_reset_value_kind = "numeric";
        l4_reset_value_source = "scalar_prose_adjacency_v1_6_503";
        l4_access_literal = "WARL";
        field { sw = rw; reset = 32'h1; desc = "Machine Performance-Monitoring Counter"; l4_access_inherited = true; l4_synthesised_source = "summary_table_only"; l4_synthesised_whole_register_field = true; l4_access_literal = "WARL"; } WHOLE_REG[31:0];
    } mhpmcounter31 @ 0x2C7C;
    reg {
        regwidth = 32;
        desc = "Upper 32 bits of ``mcycle";
        l4_evidence = "input/docs/ibex_cs_registers.rst";
        l4_extraction_strategy = "rst_grid_csr_v1_6_566";
        l4_is_counter = true;
        l4_access_literal = "RW";
        field { sw = rw; desc = "Upper 32 bits of ``mcycle``"; l4_access_inherited = true; l4_synthesised_source = "summary_table_only"; l4_synthesised_whole_register_field = true; l4_access_literal = "RW"; } WHOLE_REG[31:0];
    } mcycleh @ 0x2E00;
    reg {
        regwidth = 32;
        desc = "Upper 32 bits of ``minstret";
        l4_evidence = "input/docs/ibex_cs_registers.rst";
        l4_extraction_strategy = "rst_grid_csr_v1_6_566";
        l4_is_counter = true;
        l4_access_literal = "RW";
        field { sw = rw; desc = "Upper 32 bits of ``minstret``"; l4_access_inherited = true; l4_synthesised_source = "summary_table_only"; l4_synthesised_whole_register_field = true; l4_access_literal = "RW"; } WHOLE_REG[31:0];
    } minstreth @ 0x2E08;
    reg {
        regwidth = 32;
        desc = "Upper 32 bits of ``mhmpcounter3";
        l4_evidence = "input/docs/ibex_cs_registers.rst";
        l4_extraction_strategy = "rst_grid_csr_v1_6_566";
        l4_is_counter = true;
        l4_access_literal = "WARL";
        field { sw = rw; desc = "Upper 32 bits of ``mhmpcounter3``"; l4_access_inherited = true; l4_synthesised_source = "summary_table_only"; l4_synthesised_whole_register_field = true; l4_access_literal = "WARL"; } WHOLE_REG[31:0];
    } mhpmcounter3h @ 0x2E0C;
    reg {
        regwidth = 32;
        desc = "Upper 32 bits of ``mhmpcounter31";
        l4_evidence = "input/docs/ibex_cs_registers.rst";
        l4_extraction_strategy = "rst_grid_csr_v1_6_566";
        l4_is_counter = true;
        l4_access_literal = "WARL";
        field { sw = rw; desc = "Upper 32 bits of ``mhmpcounter31``"; l4_access_inherited = true; l4_synthesised_source = "summary_table_only"; l4_synthesised_whole_register_field = true; l4_access_literal = "WARL"; } WHOLE_REG[31:0];
    } mhpmcounter31h @ 0x2E7C;
    reg {
        regwidth = 32;
        l4_evidence = "input/docs/ibex_cs_registers.rst";
        l4_extraction_strategy = "asciidoc_rowspan_fields";
        l4_reset_value_kind = "numeric";
        l4_access_literal = "";
        field { reset = 15'h0; desc = "Machine Fast Interrupts Pending: If bit x+16 is set,"; l4_access_inherited = false; l4_extraction_strategy = "asciidoc_rowspan_fields_bits_fallback"; l4_access_literal = ""; } BITS_30_16[30:16];
        field { reset = 1'h0; desc = "If set, ``irq_external_i`` is pending."; l4_access_inherited = false; l4_access_literal = ""; } MEIP[11:11];
        field { reset = 1'h0; desc = "If set, ``irq_timer_i`` is pending."; l4_access_inherited = false; l4_access_literal = ""; } MTIP[7:7];
        field { reset = 1'h0; desc = "if set, ``irq_software_i`` is pending."; l4_access_inherited = false; l4_access_literal = ""; } MSIP[3:3];
    } csr_344 @ 0xD10;
    reg {
        regwidth = 32;
        desc = "reset=0x0000_0000";
        l4_evidence = "input/docs/ibex_cs_registers.rst";
        l4_access_literal = "R/W";
        field { sw = rw; reset = 32'h0; desc = "reset=0x0000_0000"; l4_access_inherited = true; l4_synthesised_source = "summary_table_only"; l4_synthesised_whole_register_field = true; l4_access_literal = "R/W"; } WHOLE_REG[31:0];
    } csr_f11 @ 0x3C44;
    reg {
        regwidth = 32;
        desc = "reset=0x0000_0016";
        l4_evidence = "input/docs/ibex_cs_registers.rst";
        l4_access_literal = "R/W";
        field { sw = rw; reset = 32'h16; desc = "reset=0x0000_0016"; l4_access_inherited = true; l4_synthesised_source = "summary_table_only"; l4_synthesised_whole_register_field = true; l4_access_literal = "R/W"; } WHOLE_REG[31:0];
    } csr_f12 @ 0x3C48;
    reg {
        regwidth = 32;
        desc = "reset=0x0000_0000";
        l4_evidence = "input/docs/ibex_cs_registers.rst";
        l4_access_literal = "R/W";
        field { sw = rw; reset = 32'h0; desc = "reset=0x0000_0000"; l4_access_inherited = true; l4_synthesised_source = "summary_table_only"; l4_synthesised_whole_register_field = true; l4_access_literal = "R/W"; } WHOLE_REG[31:0];
    } csr_f13 @ 0x3C4C;
    reg {
        regwidth = 32;
        desc = "reset=unspecified";
        l4_evidence = "input/docs/ibex_cs_registers.rst";
        l4_access_literal = "R/W";
        field { sw = rw; desc = "reset=unspecified"; l4_access_inherited = true; l4_synthesised_source = "summary_table_only"; l4_synthesised_whole_register_field = true; l4_access_literal = "R/W"; } WHOLE_REG[31:0];
    } csr_f14 @ 0x3C50;
};
