* NGSPICE file created from spm.ext - technology: sky130A

.subckt sky130_fd_sc_hd__nor3_1 VPB VNB VGND VPWR C B A Y
X0 VPWR A a_193_297# VPB sky130_fd_pr__pfet_01v8_hvt ad=0.26 pd=2.52 as=0.135 ps=1.27 w=1 l=0.15
X1 a_193_297# B a_109_297# VPB sky130_fd_pr__pfet_01v8_hvt ad=0.135 pd=1.27 as=0.135 ps=1.27 w=1 l=0.15
X2 Y B VGND VNB sky130_fd_pr__nfet_01v8 ad=0.08775 pd=0.92 as=0.08775 ps=0.92 w=0.65 l=0.15
X3 VGND A Y VNB sky130_fd_pr__nfet_01v8 ad=0.169 pd=1.82 as=0.08775 ps=0.92 w=0.65 l=0.15
X4 a_109_297# C Y VPB sky130_fd_pr__pfet_01v8_hvt ad=0.135 pd=1.27 as=0.26 ps=2.52 w=1 l=0.15
X5 VGND C Y VNB sky130_fd_pr__nfet_01v8 ad=0.08775 pd=0.92 as=0.169 ps=1.82 w=0.65 l=0.15
.ends

.subckt sky130_fd_sc_hd__a21oi_1 VPWR VGND VPB VNB A2 A1 B1 Y
X0 a_199_47# A1 Y VNB sky130_fd_pr__nfet_01v8 ad=0.09588 pd=0.945 as=0.091 ps=0.93 w=0.65 l=0.15
X1 a_113_297# A2 VPWR VPB sky130_fd_pr__pfet_01v8_hvt ad=0.265 pd=2.53 as=0.1475 ps=1.295 w=1 l=0.15
X2 Y B1 VGND VNB sky130_fd_pr__nfet_01v8 ad=0.091 pd=0.93 as=0.17225 ps=1.83 w=0.65 l=0.15
X3 VPWR A1 a_113_297# VPB sky130_fd_pr__pfet_01v8_hvt ad=0.1475 pd=1.295 as=0.14 ps=1.28 w=1 l=0.15
X4 a_113_297# B1 Y VPB sky130_fd_pr__pfet_01v8_hvt ad=0.14 pd=1.28 as=0.265 ps=2.53 w=1 l=0.15
X5 VGND A2 a_199_47# VNB sky130_fd_pr__nfet_01v8 ad=0.17225 pd=1.83 as=0.09588 ps=0.945 w=0.65 l=0.15
.ends

.subckt sky130_fd_sc_hd__nor3b_1 VPB VNB VGND VPWR C_N B Y A
X0 VGND a_91_199# Y VNB sky130_fd_pr__nfet_01v8 ad=0.08775 pd=0.92 as=0.221 ps=1.98 w=0.65 l=0.15
X1 Y B VGND VNB sky130_fd_pr__nfet_01v8 ad=0.08775 pd=0.92 as=0.08775 ps=0.92 w=0.65 l=0.15
X2 VPWR A a_245_297# VPB sky130_fd_pr__pfet_01v8_hvt ad=0.14575 pd=1.335 as=0.135 ps=1.27 w=1 l=0.15
X3 a_91_199# C_N VGND VNB sky130_fd_pr__nfet_01v8 ad=0.1092 pd=1.36 as=0.10025 ps=0.985 w=0.42 l=0.15
X4 VGND A Y VNB sky130_fd_pr__nfet_01v8 ad=0.10025 pd=0.985 as=0.08775 ps=0.92 w=0.65 l=0.15
X5 a_245_297# B a_161_297# VPB sky130_fd_pr__pfet_01v8_hvt ad=0.135 pd=1.27 as=0.135 ps=1.27 w=1 l=0.15
X6 a_91_199# C_N VPWR VPB sky130_fd_pr__pfet_01v8_hvt ad=0.1092 pd=1.36 as=0.14575 ps=1.335 w=0.42 l=0.15
X7 a_161_297# a_91_199# Y VPB sky130_fd_pr__pfet_01v8_hvt ad=0.135 pd=1.27 as=0.32 ps=2.64 w=1 l=0.15
.ends

.subckt sky130_fd_sc_hd__nand3_1 VPB VNB VGND VPWR A B Y C
X0 VPWR B Y VPB sky130_fd_pr__pfet_01v8_hvt ad=0.165 pd=1.33 as=0.135 ps=1.27 w=1 l=0.15
X1 Y A VPWR VPB sky130_fd_pr__pfet_01v8_hvt ad=0.26 pd=2.52 as=0.165 ps=1.33 w=1 l=0.15
X2 a_193_47# B a_109_47# VNB sky130_fd_pr__nfet_01v8 ad=0.10725 pd=0.98 as=0.08775 ps=0.92 w=0.65 l=0.15
X3 Y A a_193_47# VNB sky130_fd_pr__nfet_01v8 ad=0.169 pd=1.82 as=0.10725 ps=0.98 w=0.65 l=0.15
X4 Y C VPWR VPB sky130_fd_pr__pfet_01v8_hvt ad=0.135 pd=1.27 as=0.26 ps=2.52 w=1 l=0.15
X5 a_109_47# C VGND VNB sky130_fd_pr__nfet_01v8 ad=0.08775 pd=0.92 as=0.169 ps=1.82 w=0.65 l=0.15
.ends

.subckt sky130_fd_sc_hd__dfxtp_1 Q CLK D VPB VNB VPWR VGND
X0 Q a_1059_315# VGND VNB sky130_fd_pr__nfet_01v8 ad=0.169 pd=1.82 as=0.08775 ps=0.92 w=0.65 l=0.15
X1 a_891_413# a_193_47# a_634_159# VNB sky130_fd_pr__special_nfet_01v8 ad=0.0684 pd=0.74 as=0.0989 ps=0.995 w=0.36 l=0.15
X2 a_561_413# a_27_47# a_466_413# VPB sky130_fd_pr__pfet_01v8_hvt ad=0.07665 pd=0.785 as=0.06825 ps=0.745 w=0.42 l=0.15
X3 VPWR CLK a_27_47# VPB sky130_fd_pr__pfet_01v8_hvt ad=0.0864 pd=0.91 as=0.1664 ps=1.8 w=0.64 l=0.15
X4 Q a_1059_315# VPWR VPB sky130_fd_pr__pfet_01v8_hvt ad=0.26 pd=2.52 as=0.135 ps=1.27 w=1 l=0.15
X5 a_381_47# D VPWR VPB sky130_fd_pr__pfet_01v8_hvt ad=0.05775 pd=0.695 as=0.1092 ps=1.36 w=0.42 l=0.15
X6 VGND a_634_159# a_592_47# VNB sky130_fd_pr__nfet_01v8 ad=0.12095 pd=1.085 as=0.0696 ps=0.765 w=0.42 l=0.15
X7 VPWR a_891_413# a_1059_315# VPB sky130_fd_pr__pfet_01v8_hvt ad=0.135 pd=1.27 as=0.27 ps=2.54 w=1 l=0.15
X8 a_466_413# a_193_47# a_381_47# VPB sky130_fd_pr__pfet_01v8_hvt ad=0.06825 pd=0.745 as=0.05775 ps=0.695 w=0.42 l=0.15
X9 VPWR a_634_159# a_561_413# VPB sky130_fd_pr__pfet_01v8_hvt ad=0.17887 pd=1.26 as=0.07665 ps=0.785 w=0.42 l=0.15
X10 a_634_159# a_466_413# VGND VNB sky130_fd_pr__nfet_01v8 ad=0.0989 pd=0.995 as=0.12095 ps=1.085 w=0.64 l=0.15
X11 a_634_159# a_466_413# VPWR VPB sky130_fd_pr__pfet_01v8_hvt ad=0.1095 pd=1.075 as=0.17887 ps=1.26 w=0.75 l=0.15
X12 a_975_413# a_193_47# a_891_413# VPB sky130_fd_pr__pfet_01v8_hvt ad=0.0882 pd=0.84 as=0.0567 ps=0.69 w=0.42 l=0.15
X13 VGND a_1059_315# a_1017_47# VNB sky130_fd_pr__nfet_01v8 ad=0.1092 pd=1.36 as=0.066 ps=0.745 w=0.42 l=0.15
X14 a_193_47# a_27_47# VGND VNB sky130_fd_pr__nfet_01v8 ad=0.1092 pd=1.36 as=0.0567 ps=0.69 w=0.42 l=0.15
X15 a_891_413# a_27_47# a_634_159# VPB sky130_fd_pr__pfet_01v8_hvt ad=0.0567 pd=0.69 as=0.1095 ps=1.075 w=0.42 l=0.15
X16 a_592_47# a_193_47# a_466_413# VNB sky130_fd_pr__special_nfet_01v8 ad=0.0696 pd=0.765 as=0.0621 ps=0.705 w=0.36 l=0.15
X17 VPWR a_1059_315# a_975_413# VPB sky130_fd_pr__pfet_01v8_hvt ad=0.1113 pd=1.37 as=0.0882 ps=0.84 w=0.42 l=0.15
X18 a_1017_47# a_27_47# a_891_413# VNB sky130_fd_pr__special_nfet_01v8 ad=0.066 pd=0.745 as=0.0684 ps=0.74 w=0.36 l=0.15
X19 a_193_47# a_27_47# VPWR VPB sky130_fd_pr__pfet_01v8_hvt ad=0.1664 pd=1.8 as=0.0864 ps=0.91 w=0.64 l=0.15
X20 a_466_413# a_27_47# a_381_47# VNB sky130_fd_pr__special_nfet_01v8 ad=0.0621 pd=0.705 as=0.0813 ps=0.83 w=0.36 l=0.15
X21 VGND a_891_413# a_1059_315# VNB sky130_fd_pr__nfet_01v8 ad=0.08775 pd=0.92 as=0.169 ps=1.82 w=0.65 l=0.15
X22 a_381_47# D VGND VNB sky130_fd_pr__nfet_01v8 ad=0.0813 pd=0.83 as=0.1092 ps=1.36 w=0.42 l=0.15
X23 VGND CLK a_27_47# VNB sky130_fd_pr__nfet_01v8 ad=0.0567 pd=0.69 as=0.1092 ps=1.36 w=0.42 l=0.15
.ends

.subckt sky130_fd_sc_hd__a21o_1 VPWR VGND VPB VNB A2 A1 B1 X
X0 a_81_21# B1 VGND VNB sky130_fd_pr__nfet_01v8 ad=0.08937 pd=0.925 as=0.25675 ps=1.44 w=0.65 l=0.15
X1 a_299_297# B1 a_81_21# VPB sky130_fd_pr__pfet_01v8_hvt ad=0.1375 pd=1.275 as=0.26 ps=2.52 w=1 l=0.15
X2 VPWR a_81_21# X VPB sky130_fd_pr__pfet_01v8_hvt ad=0.26 pd=2.52 as=0.26 ps=2.52 w=1 l=0.15
X3 VPWR A1 a_299_297# VPB sky130_fd_pr__pfet_01v8_hvt ad=0.14 pd=1.28 as=0.1375 ps=1.275 w=1 l=0.15
X4 VGND a_81_21# X VNB sky130_fd_pr__nfet_01v8 ad=0.25675 pd=1.44 as=0.169 ps=1.82 w=0.65 l=0.15
X5 VGND A2 a_384_47# VNB sky130_fd_pr__nfet_01v8 ad=0.17225 pd=1.83 as=0.091 ps=0.93 w=0.65 l=0.15
X6 a_299_297# A2 VPWR VPB sky130_fd_pr__pfet_01v8_hvt ad=0.265 pd=2.53 as=0.14 ps=1.28 w=1 l=0.15
X7 a_384_47# A1 a_81_21# VNB sky130_fd_pr__nfet_01v8 ad=0.091 pd=0.93 as=0.08937 ps=0.925 w=0.65 l=0.15
.ends

.subckt sky130_fd_sc_hd__and3_1 VGND VPWR X B A C VPB VNB
X0 VPWR A a_27_47# VPB sky130_fd_pr__pfet_01v8_hvt ad=0.0567 pd=0.69 as=0.1092 ps=1.36 w=0.42 l=0.15
X1 VPWR C a_27_47# VPB sky130_fd_pr__pfet_01v8_hvt ad=0.14222 pd=1.335 as=0.06615 ps=0.735 w=0.42 l=0.15
X2 a_181_47# B a_109_47# VNB sky130_fd_pr__nfet_01v8 ad=0.0441 pd=0.63 as=0.0441 ps=0.63 w=0.42 l=0.15
X3 VGND C a_181_47# VNB sky130_fd_pr__nfet_01v8 ad=0.13165 pd=1.14 as=0.0441 ps=0.63 w=0.42 l=0.15
X4 a_27_47# B VPWR VPB sky130_fd_pr__pfet_01v8_hvt ad=0.06615 pd=0.735 as=0.0567 ps=0.69 w=0.42 l=0.15
X5 X a_27_47# VPWR VPB sky130_fd_pr__pfet_01v8_hvt ad=0.26 pd=2.52 as=0.14222 ps=1.335 w=1 l=0.15
X6 X a_27_47# VGND VNB sky130_fd_pr__nfet_01v8 ad=0.169 pd=1.82 as=0.13165 ps=1.14 w=0.65 l=0.15
X7 a_109_47# A a_27_47# VNB sky130_fd_pr__nfet_01v8 ad=0.0441 pd=0.63 as=0.1092 ps=1.36 w=0.42 l=0.15
.ends

.subckt sky130_fd_sc_hd__clkbuf_8 X A VPB VNB VGND VPWR
X0 VPWR A a_110_47# VPB sky130_fd_pr__pfet_01v8_hvt ad=0.14 pd=1.28 as=0.14 ps=1.28 w=1 l=0.15
X1 VPWR a_110_47# X VPB sky130_fd_pr__pfet_01v8_hvt ad=0.14 pd=1.28 as=0.14 ps=1.28 w=1 l=0.15
X2 X a_110_47# VPWR VPB sky130_fd_pr__pfet_01v8_hvt ad=0.14 pd=1.28 as=0.14 ps=1.28 w=1 l=0.15
X3 a_110_47# A VPWR VPB sky130_fd_pr__pfet_01v8_hvt ad=0.14 pd=1.28 as=0.265 ps=2.53 w=1 l=0.15
X4 X a_110_47# VGND VNB sky130_fd_pr__nfet_01v8 ad=0.0588 pd=0.7 as=0.0588 ps=0.7 w=0.42 l=0.15
X5 X a_110_47# VPWR VPB sky130_fd_pr__pfet_01v8_hvt ad=0.14 pd=1.28 as=0.14 ps=1.28 w=1 l=0.15
X6 VGND a_110_47# X VNB sky130_fd_pr__nfet_01v8 ad=0.0588 pd=0.7 as=0.0588 ps=0.7 w=0.42 l=0.15
X7 VPWR a_110_47# X VPB sky130_fd_pr__pfet_01v8_hvt ad=0.14 pd=1.28 as=0.14 ps=1.28 w=1 l=0.15
X8 VGND A a_110_47# VNB sky130_fd_pr__nfet_01v8 ad=0.0588 pd=0.7 as=0.0588 ps=0.7 w=0.42 l=0.15
X9 VGND a_110_47# X VNB sky130_fd_pr__nfet_01v8 ad=0.1134 pd=1.38 as=0.0588 ps=0.7 w=0.42 l=0.15
X10 a_110_47# A VGND VNB sky130_fd_pr__nfet_01v8 ad=0.0588 pd=0.7 as=0.1113 ps=1.37 w=0.42 l=0.15
X11 VPWR a_110_47# X VPB sky130_fd_pr__pfet_01v8_hvt ad=0.14 pd=1.28 as=0.14 ps=1.28 w=1 l=0.15
X12 X a_110_47# VPWR VPB sky130_fd_pr__pfet_01v8_hvt ad=0.14 pd=1.28 as=0.14 ps=1.28 w=1 l=0.15
X13 VGND a_110_47# X VNB sky130_fd_pr__nfet_01v8 ad=0.0588 pd=0.7 as=0.0588 ps=0.7 w=0.42 l=0.15
X14 VGND a_110_47# X VNB sky130_fd_pr__nfet_01v8 ad=0.0588 pd=0.7 as=0.0588 ps=0.7 w=0.42 l=0.15
X15 X a_110_47# VPWR VPB sky130_fd_pr__pfet_01v8_hvt ad=0.14 pd=1.28 as=0.14 ps=1.28 w=1 l=0.15
X16 X a_110_47# VGND VNB sky130_fd_pr__nfet_01v8 ad=0.0588 pd=0.7 as=0.0588 ps=0.7 w=0.42 l=0.15
X17 VPWR a_110_47# X VPB sky130_fd_pr__pfet_01v8_hvt ad=0.265 pd=2.53 as=0.14 ps=1.28 w=1 l=0.15
X18 X a_110_47# VGND VNB sky130_fd_pr__nfet_01v8 ad=0.0588 pd=0.7 as=0.0588 ps=0.7 w=0.42 l=0.15
X19 X a_110_47# VGND VNB sky130_fd_pr__nfet_01v8 ad=0.0588 pd=0.7 as=0.0588 ps=0.7 w=0.42 l=0.15
.ends

.subckt sky130_fd_sc_hd__a31oi_1 VGND VPWR VPB VNB A3 A2 A1 Y B1
X0 Y A1 a_181_47# VNB sky130_fd_pr__nfet_01v8 ad=0.10563 pd=0.975 as=0.11863 ps=1.015 w=0.65 l=0.15
X1 a_181_47# A2 a_109_47# VNB sky130_fd_pr__nfet_01v8 ad=0.11863 pd=1.015 as=0.06825 ps=0.86 w=0.65 l=0.15
X2 VGND B1 Y VNB sky130_fd_pr__nfet_01v8 ad=0.1755 pd=1.84 as=0.10563 ps=0.975 w=0.65 l=0.15
X3 VPWR A2 a_109_297# VPB sky130_fd_pr__pfet_01v8_hvt ad=0.1525 pd=1.305 as=0.135 ps=1.27 w=1 l=0.15
X4 Y B1 a_109_297# VPB sky130_fd_pr__pfet_01v8_hvt ad=0.27 pd=2.54 as=0.1625 ps=1.325 w=1 l=0.15
X5 a_109_297# A1 VPWR VPB sky130_fd_pr__pfet_01v8_hvt ad=0.1625 pd=1.325 as=0.1525 ps=1.305 w=1 l=0.15
X6 a_109_297# A3 VPWR VPB sky130_fd_pr__pfet_01v8_hvt ad=0.135 pd=1.27 as=0.26 ps=2.52 w=1 l=0.15
X7 a_109_47# A3 VGND VNB sky130_fd_pr__nfet_01v8 ad=0.06825 pd=0.86 as=0.169 ps=1.82 w=0.65 l=0.15
.ends

.subckt sky130_fd_sc_hd__and2_0 VNB VPB VPWR VGND X B A
X0 VPWR B a_40_47# VPB sky130_fd_pr__pfet_01v8_hvt ad=0.1841 pd=1.26 as=0.0609 ps=0.71 w=0.42 l=0.15
X1 X a_40_47# VPWR VPB sky130_fd_pr__pfet_01v8_hvt ad=0.1696 pd=1.81 as=0.1841 ps=1.26 w=0.64 l=0.15
X2 VGND B a_123_47# VNB sky130_fd_pr__nfet_01v8 ad=0.0966 pd=0.88 as=0.0441 ps=0.63 w=0.42 l=0.15
X3 X a_40_47# VGND VNB sky130_fd_pr__nfet_01v8 ad=0.1113 pd=1.37 as=0.0966 ps=0.88 w=0.42 l=0.15
X4 a_123_47# A a_40_47# VNB sky130_fd_pr__nfet_01v8 ad=0.0441 pd=0.63 as=0.1113 ps=1.37 w=0.42 l=0.15
X5 a_40_47# A VPWR VPB sky130_fd_pr__pfet_01v8_hvt ad=0.0609 pd=0.71 as=0.1113 ps=1.37 w=0.42 l=0.15
.ends

.subckt sky130_fd_sc_hd__nor2_1 VPB VNB VGND VPWR A B Y
X0 VPWR A a_109_297# VPB sky130_fd_pr__pfet_01v8_hvt ad=0.26 pd=2.52 as=0.105 ps=1.21 w=1 l=0.15
X1 VGND A Y VNB sky130_fd_pr__nfet_01v8 ad=0.169 pd=1.82 as=0.08775 ps=0.92 w=0.65 l=0.15
X2 a_109_297# B Y VPB sky130_fd_pr__pfet_01v8_hvt ad=0.105 pd=1.21 as=0.26 ps=2.52 w=1 l=0.15
X3 Y B VGND VNB sky130_fd_pr__nfet_01v8 ad=0.08775 pd=0.92 as=0.169 ps=1.82 w=0.65 l=0.15
.ends

.subckt sky130_fd_sc_hd__bufinv_16 VNB VPB VGND VPWR A Y
X0 a_361_47# a_27_47# VGND VNB sky130_fd_pr__nfet_01v8 ad=0.08775 pd=0.92 as=0.08775 ps=0.92 w=0.65 l=0.15
X1 VPWR a_361_47# Y VPB sky130_fd_pr__pfet_01v8_hvt ad=0.135 pd=1.27 as=0.135 ps=1.27 w=1 l=0.15
X2 a_361_47# a_27_47# VGND VNB sky130_fd_pr__nfet_01v8 ad=0.08775 pd=0.92 as=0.08775 ps=0.92 w=0.65 l=0.15
X3 Y a_361_47# VGND VNB sky130_fd_pr__nfet_01v8 ad=0.08775 pd=0.92 as=0.08775 ps=0.92 w=0.65 l=0.15
X4 VPWR a_361_47# Y VPB sky130_fd_pr__pfet_01v8_hvt ad=0.135 pd=1.27 as=0.135 ps=1.27 w=1 l=0.15
X5 Y a_361_47# VGND VNB sky130_fd_pr__nfet_01v8 ad=0.08775 pd=0.92 as=0.08775 ps=0.92 w=0.65 l=0.15
X6 Y a_361_47# VPWR VPB sky130_fd_pr__pfet_01v8_hvt ad=0.135 pd=1.27 as=0.135 ps=1.27 w=1 l=0.15
X7 VPWR a_27_47# a_361_47# VPB sky130_fd_pr__pfet_01v8_hvt ad=0.135 pd=1.27 as=0.135 ps=1.27 w=1 l=0.15
X8 VPWR a_361_47# Y VPB sky130_fd_pr__pfet_01v8_hvt ad=0.26 pd=2.52 as=0.135 ps=1.27 w=1 l=0.15
X9 VPWR a_361_47# Y VPB sky130_fd_pr__pfet_01v8_hvt ad=0.135 pd=1.27 as=0.135 ps=1.27 w=1 l=0.15
X10 VGND a_361_47# Y VNB sky130_fd_pr__nfet_01v8 ad=0.169 pd=1.82 as=0.08775 ps=0.92 w=0.65 l=0.15
X11 a_361_47# a_27_47# VPWR VPB sky130_fd_pr__pfet_01v8_hvt ad=0.135 pd=1.27 as=0.135 ps=1.27 w=1 l=0.15
X12 VGND a_361_47# Y VNB sky130_fd_pr__nfet_01v8 ad=0.08775 pd=0.92 as=0.08775 ps=0.92 w=0.65 l=0.15
X13 VGND a_361_47# Y VNB sky130_fd_pr__nfet_01v8 ad=0.08775 pd=0.92 as=0.08775 ps=0.92 w=0.65 l=0.15
X14 VGND a_361_47# Y VNB sky130_fd_pr__nfet_01v8 ad=0.08775 pd=0.92 as=0.08775 ps=0.92 w=0.65 l=0.15
X15 VGND a_361_47# Y VNB sky130_fd_pr__nfet_01v8 ad=0.08775 pd=0.92 as=0.08775 ps=0.92 w=0.65 l=0.15
X16 VPWR A a_27_47# VPB sky130_fd_pr__pfet_01v8_hvt ad=0.135 pd=1.27 as=0.135 ps=1.27 w=1 l=0.15
X17 Y a_361_47# VPWR VPB sky130_fd_pr__pfet_01v8_hvt ad=0.135 pd=1.27 as=0.135 ps=1.27 w=1 l=0.15
X18 VGND a_361_47# Y VNB sky130_fd_pr__nfet_01v8 ad=0.08775 pd=0.92 as=0.08775 ps=0.92 w=0.65 l=0.15
X19 VPWR a_361_47# Y VPB sky130_fd_pr__pfet_01v8_hvt ad=0.135 pd=1.27 as=0.135 ps=1.27 w=1 l=0.15
X20 a_27_47# A VPWR VPB sky130_fd_pr__pfet_01v8_hvt ad=0.135 pd=1.27 as=0.135 ps=1.27 w=1 l=0.15
X21 Y a_361_47# VPWR VPB sky130_fd_pr__pfet_01v8_hvt ad=0.135 pd=1.27 as=0.135 ps=1.27 w=1 l=0.15
X22 a_27_47# A VGND VNB sky130_fd_pr__nfet_01v8 ad=0.08775 pd=0.92 as=0.08775 ps=0.92 w=0.65 l=0.15
X23 a_361_47# a_27_47# VGND VNB sky130_fd_pr__nfet_01v8 ad=0.08775 pd=0.92 as=0.08775 ps=0.92 w=0.65 l=0.15
X24 Y a_361_47# VPWR VPB sky130_fd_pr__pfet_01v8_hvt ad=0.135 pd=1.27 as=0.135 ps=1.27 w=1 l=0.15
X25 Y a_361_47# VGND VNB sky130_fd_pr__nfet_01v8 ad=0.08775 pd=0.92 as=0.08775 ps=0.92 w=0.65 l=0.15
X26 VPWR a_27_47# a_361_47# VPB sky130_fd_pr__pfet_01v8_hvt ad=0.135 pd=1.27 as=0.135 ps=1.27 w=1 l=0.15
X27 Y a_361_47# VGND VNB sky130_fd_pr__nfet_01v8 ad=0.08775 pd=0.92 as=0.08775 ps=0.92 w=0.65 l=0.15
X28 Y a_361_47# VPWR VPB sky130_fd_pr__pfet_01v8_hvt ad=0.135 pd=1.27 as=0.135 ps=1.27 w=1 l=0.15
X29 Y a_361_47# VGND VNB sky130_fd_pr__nfet_01v8 ad=0.08775 pd=0.92 as=0.08775 ps=0.92 w=0.65 l=0.15
X30 a_361_47# a_27_47# VPWR VPB sky130_fd_pr__pfet_01v8_hvt ad=0.135 pd=1.27 as=0.135 ps=1.27 w=1 l=0.15
X31 VPWR a_361_47# Y VPB sky130_fd_pr__pfet_01v8_hvt ad=0.135 pd=1.27 as=0.135 ps=1.27 w=1 l=0.15
X32 Y a_361_47# VGND VNB sky130_fd_pr__nfet_01v8 ad=0.08775 pd=0.92 as=0.08775 ps=0.92 w=0.65 l=0.15
X33 VGND A a_27_47# VNB sky130_fd_pr__nfet_01v8 ad=0.08775 pd=0.92 as=0.08775 ps=0.92 w=0.65 l=0.15
X34 VGND a_27_47# a_361_47# VNB sky130_fd_pr__nfet_01v8 ad=0.08775 pd=0.92 as=0.08775 ps=0.92 w=0.65 l=0.15
X35 VPWR a_27_47# a_361_47# VPB sky130_fd_pr__pfet_01v8_hvt ad=0.135 pd=1.27 as=0.135 ps=1.27 w=1 l=0.15
X36 Y a_361_47# VPWR VPB sky130_fd_pr__pfet_01v8_hvt ad=0.135 pd=1.27 as=0.135 ps=1.27 w=1 l=0.15
X37 VGND a_27_47# a_361_47# VNB sky130_fd_pr__nfet_01v8 ad=0.08775 pd=0.92 as=0.08775 ps=0.92 w=0.65 l=0.15
X38 VGND a_27_47# a_361_47# VNB sky130_fd_pr__nfet_01v8 ad=0.08775 pd=0.92 as=0.08775 ps=0.92 w=0.65 l=0.15
X39 a_361_47# a_27_47# VPWR VPB sky130_fd_pr__pfet_01v8_hvt ad=0.135 pd=1.27 as=0.135 ps=1.27 w=1 l=0.15
X40 VPWR a_361_47# Y VPB sky130_fd_pr__pfet_01v8_hvt ad=0.135 pd=1.27 as=0.135 ps=1.27 w=1 l=0.15
X41 VPWR a_361_47# Y VPB sky130_fd_pr__pfet_01v8_hvt ad=0.135 pd=1.27 as=0.135 ps=1.27 w=1 l=0.15
X42 VGND a_361_47# Y VNB sky130_fd_pr__nfet_01v8 ad=0.08775 pd=0.92 as=0.08775 ps=0.92 w=0.65 l=0.15
X43 VGND a_361_47# Y VNB sky130_fd_pr__nfet_01v8 ad=0.08775 pd=0.92 as=0.08775 ps=0.92 w=0.65 l=0.15
X44 VPWR A a_27_47# VPB sky130_fd_pr__pfet_01v8_hvt ad=0.135 pd=1.27 as=0.26 ps=2.52 w=1 l=0.15
X45 Y a_361_47# VPWR VPB sky130_fd_pr__pfet_01v8_hvt ad=0.135 pd=1.27 as=0.135 ps=1.27 w=1 l=0.15
X46 Y a_361_47# VGND VNB sky130_fd_pr__nfet_01v8 ad=0.08775 pd=0.92 as=0.08775 ps=0.92 w=0.65 l=0.15
X47 Y a_361_47# VPWR VPB sky130_fd_pr__pfet_01v8_hvt ad=0.135 pd=1.27 as=0.135 ps=1.27 w=1 l=0.15
X48 VGND A a_27_47# VNB sky130_fd_pr__nfet_01v8 ad=0.08775 pd=0.92 as=0.169 ps=1.82 w=0.65 l=0.15
X49 Y a_361_47# VGND VNB sky130_fd_pr__nfet_01v8 ad=0.08775 pd=0.92 as=0.08775 ps=0.92 w=0.65 l=0.15
.ends

.subckt sky130_fd_sc_hd__clkbuf_1 VGND VPWR X A VPB VNB
X0 VPWR a_75_212# X VPB sky130_fd_pr__pfet_01v8_hvt ad=0.11455 pd=1.08 as=0.2054 ps=2.1 w=0.79 l=0.15
X1 a_75_212# A VGND VNB sky130_fd_pr__nfet_01v8 ad=0.1352 pd=1.56 as=0.0754 ps=0.81 w=0.52 l=0.15
X2 a_75_212# A VPWR VPB sky130_fd_pr__pfet_01v8_hvt ad=0.2054 pd=2.1 as=0.11455 ps=1.08 w=0.79 l=0.15
X3 VGND a_75_212# X VNB sky130_fd_pr__nfet_01v8 ad=0.0754 pd=0.81 as=0.1352 ps=1.56 w=0.52 l=0.15
.ends

.subckt sky130_fd_sc_hd__clkinv_2 VNB VPB VPWR VGND A Y
X0 Y A VGND VNB sky130_fd_pr__nfet_01v8 ad=0.0588 pd=0.7 as=0.1113 ps=1.37 w=0.42 l=0.15
X1 Y A VPWR VPB sky130_fd_pr__pfet_01v8_hvt ad=0.14 pd=1.28 as=0.14 ps=1.28 w=1 l=0.15
X2 VPWR A Y VPB sky130_fd_pr__pfet_01v8_hvt ad=0.14 pd=1.28 as=0.265 ps=2.53 w=1 l=0.15
X3 VGND A Y VNB sky130_fd_pr__nfet_01v8 ad=0.1092 pd=1.36 as=0.0588 ps=0.7 w=0.42 l=0.15
X4 VPWR A Y VPB sky130_fd_pr__pfet_01v8_hvt ad=0.265 pd=2.53 as=0.14 ps=1.28 w=1 l=0.15
.ends

.subckt spm clk p rst x[0] x[10] x[11] x[12] x[13] x[14] x[15] x[16] x[17] x[18] x[19]
+ x[1] x[20] x[21] x[22] x[23] x[24] x[25] x[26] x[27] x[28] x[29] x[2] x[30] x[31]
+ x[3] x[4] x[5] x[6] x[7] x[8] x[9] y
X_432_ _432_/VPB VSUBS _492_/VGND _459_/VPWR _432_/C _432_/B _432_/A _432_/Y sky130_fd_sc_hd__nor3_1
X_415_ _459_/VPWR _492_/VGND _415_/VPB VSUBS _415_/A2 _415_/A1 _415_/B1 _415_/Y sky130_fd_sc_hd__a21oi_1
X_294_ _485_/VPB VSUBS _435_/VGND _493_/VPWR _294_/C_N _294_/B _294_/Y _294_/A sky130_fd_sc_hd__nor3b_1
X_363_ _363_/VPB VSUBS _502_/VGND _507_/VPWR _363_/A _363_/B _363_/Y _363_/C sky130_fd_sc_hd__nand3_1
X_501_ _501_/Q _501_/CLK _501_/D _501_/VPB VSUBS _506_/VPWR _506_/VGND sky130_fd_sc_hd__dfxtp_1
X_346_ _346_/VPB VSUBS _504_/VGND _474_/VPWR _346_/C_N _346_/B _346_/Y _346_/A sky130_fd_sc_hd__nor3b_1
X_329_ _496_/VPWR _496_/VGND _461_/VPB VSUBS _329_/A2 _329_/A1 _329_/B1 _329_/X sky130_fd_sc_hd__a21o_1
X_277_ _499_/VPWR _499_/VGND _481_/VPB VSUBS _277_/A2 _277_/A1 _277_/B1 _277_/X sky130_fd_sc_hd__a21o_1
X_431_ _492_/VGND _492_/VPWR _431_/X _431_/B _431_/A _431_/C _431_/VPB VSUBS sky130_fd_sc_hd__and3_1
Xclkbuf_3_6__f_clk clkbuf_3_6__f_clk/X clkbuf_3_6__f_clk/A _483_/VPB VSUBS _435_/VGND
+ _492_/VPWR sky130_fd_sc_hd__clkbuf_8
X_293_ _493_/VPWR _493_/VGND _485_/VPB VSUBS _293_/A2 _293_/A1 _293_/B1 _293_/X sky130_fd_sc_hd__a21o_1
X_500_ _500_/Q _500_/CLK _500_/D _500_/VPB VSUBS _500_/VPWR _505_/VGND sky130_fd_sc_hd__dfxtp_1
X_362_ _362_/VPB VSUBS _502_/VGND _502_/VPWR _362_/C_N _362_/B _362_/Y _362_/A sky130_fd_sc_hd__nor3b_1
X_414_ _414_/VPB VSUBS _493_/VGND _460_/VPWR _414_/C _414_/B _414_/A _414_/Y sky130_fd_sc_hd__nor3_1
X_276_ _448_/VGND _499_/VPWR _481_/VPB VSUBS _276_/A3 _276_/A2 _276_/A1 _276_/Y _276_/B1
+ sky130_fd_sc_hd__a31oi_1
X_345_ _474_/VPWR _504_/VGND _345_/VPB VSUBS _345_/A2 _345_/A1 _345_/B1 _345_/X sky130_fd_sc_hd__a21o_1
X_328_ _448_/VGND _496_/VPWR _461_/VPB VSUBS _328_/A3 _328_/A2 _328_/A1 _328_/Y _328_/B1
+ sky130_fd_sc_hd__a31oi_1
X_259_ _387_/VPB VSUBS _502_/VGND _502_/VPWR _259_/A _259_/B _259_/Y _259_/C sky130_fd_sc_hd__nand3_1
X_430_ _459_/VPWR _492_/VGND _432_/VPB VSUBS _430_/A2 _430_/A1 _430_/B1 _430_/Y sky130_fd_sc_hd__a21oi_1
X_292_ _493_/VGND _460_/VPWR _409_/VPB VSUBS _292_/A3 _292_/A2 _292_/A1 _292_/Y _292_/B1
+ sky130_fd_sc_hd__a31oi_1
X_361_ _502_/VPWR _502_/VGND _362_/VPB VSUBS _361_/A2 _361_/A1 _361_/B1 _361_/X sky130_fd_sc_hd__a21o_1
X_413_ _493_/VGND _493_/VPWR _413_/X _413_/B _413_/A _413_/C _485_/VPB VSUBS sky130_fd_sc_hd__and3_1
X_327_ _461_/VPB VSUBS _448_/VGND _496_/VPWR _327_/A _327_/B _327_/Y _327_/C sky130_fd_sc_hd__nand3_1
X_275_ _399_/VPB VSUBS _499_/VGND _500_/VPWR _275_/A _275_/B _275_/Y _275_/C sky130_fd_sc_hd__nand3_1
X_344_ _505_/VGND _505_/VPWR _465_/VPB VSUBS _344_/A3 _344_/A2 _344_/A1 _344_/Y _344_/B1
+ sky130_fd_sc_hd__a31oi_1
X_258_ VSUBS _476_/VPB _502_/VPWR _387_/VGND _258_/X _258_/B _258_/A sky130_fd_sc_hd__and2_0
X_291_ _409_/VPB VSUBS _493_/VGND _460_/VPWR _291_/A _291_/B _291_/Y _291_/C sky130_fd_sc_hd__nand3_1
X_360_ _387_/VGND _502_/VPWR _362_/VPB VSUBS _360_/A3 _360_/A2 _360_/A1 _360_/Y _360_/B1
+ sky130_fd_sc_hd__a31oi_1
X_489_ _489_/Q _489_/CLK _489_/D _489_/VPB VSUBS _491_/VPWR _489_/VGND sky130_fd_sc_hd__dfxtp_1
X_412_ _460_/VPWR _493_/VGND _414_/VPB VSUBS _412_/A2 _412_/A1 _412_/B1 _412_/Y sky130_fd_sc_hd__a21oi_1
X_343_ _465_/VPB VSUBS _505_/VGND _505_/VPWR _343_/A _343_/B _343_/Y _343_/C sky130_fd_sc_hd__nand3_1
X_274_ _505_/VPB VSUBS _504_/VGND _505_/VPWR _274_/C_N _274_/B _274_/Y _274_/A sky130_fd_sc_hd__nor3b_1
X_309_ _492_/VPWR _492_/VGND _452_/VPB VSUBS _309_/A2 _309_/A1 _309_/B1 _309_/X sky130_fd_sc_hd__a21o_1
X_326_ _460_/VPB VSUBS _493_/VGND _460_/VPWR _326_/C_N _326_/B _326_/Y _326_/A sky130_fd_sc_hd__nor3b_1
X_257_ _476_/VPB VSUBS _387_/VGND _502_/VPWR _257_/A _257_/B _257_/Y sky130_fd_sc_hd__nor2_1
X_488_ _488_/Q _488_/CLK _488_/D _489_/VPB VSUBS _491_/VPWR _489_/VGND sky130_fd_sc_hd__dfxtp_1
X_290_ _483_/VPB VSUBS _435_/VGND _492_/VPWR _290_/C_N _290_/B _290_/Y _290_/A sky130_fd_sc_hd__nor3b_1
X_325_ _493_/VPWR _493_/VGND _493_/VPB VSUBS _325_/A2 _325_/A1 _325_/B1 _325_/X sky130_fd_sc_hd__a21o_1
X_411_ _411_/VPB VSUBS _493_/VGND _460_/VPWR _411_/C _411_/B _411_/A _411_/Y sky130_fd_sc_hd__nor3_1
X_342_ _496_/VPB VSUBS _448_/VGND _496_/VPWR _342_/C_N _342_/B _342_/Y _342_/A sky130_fd_sc_hd__nor3b_1
X_273_ _505_/VPWR _504_/VGND _505_/VPB VSUBS _273_/A2 _273_/A1 _273_/B1 _273_/X sky130_fd_sc_hd__a21o_1
X_256_ _502_/VPWR _502_/VGND _476_/VPB VSUBS _256_/A2 _256_/A1 _256_/B1 _256_/Y sky130_fd_sc_hd__a21oi_1
X_308_ _492_/VGND _492_/VPWR _452_/VPB VSUBS _308_/A3 _308_/A2 _308_/A1 _308_/Y _308_/B1
+ sky130_fd_sc_hd__a31oi_1
Xclkload0 clkload0/X clkload0/A _504_/VPB VSUBS _504_/VGND _505_/VPWR sky130_fd_sc_hd__clkbuf_8
X_239_ _507_/VGND _507_/VPWR _239_/X _239_/B _239_/A _239_/C _469_/VPB VSUBS sky130_fd_sc_hd__and3_1
Xclkbuf_3_1__f_clk clkbuf_3_1__f_clk/X clkbuf_3_1__f_clk/A _474_/VPB VSUBS _504_/VGND
+ _474_/VPWR sky130_fd_sc_hd__clkbuf_8
X_487_ _487_/Q _487_/CLK _487_/D _489_/VPB VSUBS _491_/VPWR _491_/VGND sky130_fd_sc_hd__dfxtp_1
X_410_ _493_/VGND _493_/VPWR _410_/X _410_/B _410_/A _410_/C _485_/VPB VSUBS sky130_fd_sc_hd__and3_1
X_341_ _496_/VPWR _448_/VGND _496_/VPB VSUBS _341_/A2 _341_/A1 _341_/B1 _341_/X sky130_fd_sc_hd__a21o_1
X_272_ _504_/VGND _474_/VPWR _272_/VPB VSUBS _272_/A3 _272_/A2 _272_/A1 _272_/Y _272_/B1
+ sky130_fd_sc_hd__a31oi_1
Xclkload1 clkload1/X clkload1/A _417_/VPB VSUBS _435_/VGND _492_/VPWR sky130_fd_sc_hd__clkbuf_8
X_324_ _493_/VGND _493_/VPWR _493_/VPB VSUBS _324_/A3 _324_/A2 _324_/A1 _324_/Y _324_/B1
+ sky130_fd_sc_hd__a31oi_1
X_255_ _506_/VPB VSUBS _506_/VGND _506_/VPWR _255_/C _255_/B _255_/A _255_/Y sky130_fd_sc_hd__nor3_1
X_307_ _456_/VPB VSUBS _492_/VGND _459_/VPWR _307_/A _307_/B _307_/Y _307_/C sky130_fd_sc_hd__nand3_1
X_238_ _507_/VPWR _507_/VGND _469_/VPB VSUBS _238_/A2 _238_/A1 _238_/B1 _238_/Y sky130_fd_sc_hd__a21oi_1
X_486_ _486_/Q _486_/CLK _486_/D _486_/VPB VSUBS _492_/VPWR _492_/VGND sky130_fd_sc_hd__dfxtp_1
X_323_ _493_/VPB VSUBS _435_/VGND _493_/VPWR _323_/A _323_/B _323_/Y _323_/C sky130_fd_sc_hd__nand3_1
X_340_ _448_/VGND _499_/VPWR _497_/VPB VSUBS _340_/A3 _340_/A2 _340_/A1 _340_/Y _340_/B1
+ sky130_fd_sc_hd__a31oi_1
X_469_ _469_/Q _469_/CLK _469_/D _469_/VPB VSUBS _507_/VPWR _502_/VGND sky130_fd_sc_hd__dfxtp_1
X_254_ _507_/VGND _506_/VPWR _254_/X _254_/B _254_/A _254_/C _506_/VPB VSUBS sky130_fd_sc_hd__and3_1
X_271_ _395_/VPB VSUBS _504_/VGND _474_/VPWR _271_/A _271_/B _271_/Y _271_/C sky130_fd_sc_hd__nand3_1
X_306_ _489_/VPB VSUBS _491_/VGND _491_/VPWR _306_/C_N _306_/B _306_/Y _306_/A sky130_fd_sc_hd__nor3b_1
Xclkload2 clkload2/X clkload2/A _485_/VPB VSUBS _435_/VGND _493_/VPWR sky130_fd_sc_hd__clkbuf_8
X_237_ _504_/VPB VSUBS _505_/VGND _505_/VPWR _237_/C _237_/B _237_/A _237_/Y sky130_fd_sc_hd__nor3_1
X_485_ _485_/Q _485_/CLK _485_/D _485_/VPB VSUBS _493_/VPWR _493_/VGND sky130_fd_sc_hd__dfxtp_1
X_270_ _473_/VPB VSUBS _506_/VGND _506_/VPWR _270_/C_N _270_/B _270_/Y _270_/A sky130_fd_sc_hd__nor3b_1
X_322_ _431_/VPB VSUBS _492_/VGND _492_/VPWR _322_/C_N _322_/B _322_/Y _322_/A sky130_fd_sc_hd__nor3b_1
Xclkbuf_3_7__f_clk clkbuf_3_7__f_clk/X clkbuf_3_7__f_clk/A _493_/VPB VSUBS _435_/VGND
+ _493_/VPWR sky130_fd_sc_hd__clkbuf_8
X_399_ _399_/VPB VSUBS _499_/VGND _500_/VPWR _399_/C _399_/B _399_/A _399_/Y sky130_fd_sc_hd__nor3_1
Xclkload3 VSUBS _505_/VPB _504_/VGND _505_/VPWR clkload3/A clkload3/Y sky130_fd_sc_hd__bufinv_16
X_468_ _468_/Q _468_/CLK _468_/D _504_/VPB VSUBS _505_/VPWR _504_/VGND sky130_fd_sc_hd__dfxtp_1
X_253_ _506_/VPWR _506_/VGND _506_/VPB VSUBS _253_/A2 _253_/A1 _253_/B1 _253_/Y sky130_fd_sc_hd__a21oi_1
X_305_ _491_/VPWR _491_/VGND _489_/VPB VSUBS _305_/A2 _305_/A1 _305_/B1 _305_/X sky130_fd_sc_hd__a21o_1
X_236_ _505_/VGND _505_/VPWR _236_/X _236_/B _236_/A _236_/C _504_/VPB VSUBS sky130_fd_sc_hd__and3_1
X_484_ _484_/Q _484_/CLK _484_/D _484_/VPB VSUBS _493_/VPWR _493_/VGND sky130_fd_sc_hd__dfxtp_1
Xclkbuf_0_clk clkbuf_0_clk/X clkbuf_0_clk/A _496_/VPB VSUBS _448_/VGND _496_/VPWR
+ sky130_fd_sc_hd__clkbuf_8
X_398_ _499_/VGND _499_/VPWR _398_/X _398_/B _398_/A _398_/C _481_/VPB VSUBS sky130_fd_sc_hd__and3_1
X_467_ _467_/Q _467_/CLK _467_/D _467_/VPB VSUBS _499_/VPWR _499_/VGND sky130_fd_sc_hd__dfxtp_1
X_304_ _489_/VGND _491_/VPWR _489_/VPB VSUBS _304_/A3 _304_/A2 _304_/A1 _304_/Y _304_/B1
+ sky130_fd_sc_hd__a31oi_1
X_321_ _492_/VPWR _492_/VGND _431_/VPB VSUBS _321_/A2 _321_/A1 _321_/B1 _321_/X sky130_fd_sc_hd__a21o_1
X_235_ _505_/VPWR _505_/VGND _504_/VPB VSUBS _235_/A2 _235_/A1 _235_/B1 _235_/Y sky130_fd_sc_hd__a21oi_1
X_252_ _252_/VPB VSUBS _504_/VGND _474_/VPWR _252_/C _252_/B _252_/A _252_/Y sky130_fd_sc_hd__nor3_1
Xclkload4 _504_/VGND _474_/VPWR clkload4/X clkload4/A _272_/VPB VSUBS sky130_fd_sc_hd__clkbuf_1
X_483_ _483_/Q _483_/CLK _483_/D _483_/VPB VSUBS _492_/VPWR _492_/VGND sky130_fd_sc_hd__dfxtp_1
X_320_ _435_/VGND _492_/VPWR _431_/VPB VSUBS _320_/A3 _320_/A2 _320_/A1 _320_/Y _320_/B1
+ sky130_fd_sc_hd__a31oi_1
X_397_ _499_/VPWR _499_/VGND _481_/VPB VSUBS _397_/A2 _397_/A1 _397_/B1 _397_/Y sky130_fd_sc_hd__a21oi_1
X_449_ _449_/Q _449_/CLK _449_/D _467_/VPB VSUBS _499_/VPWR _499_/VGND sky130_fd_sc_hd__dfxtp_1
X_466_ _466_/Q _466_/CLK _466_/D _466_/VPB VSUBS _500_/VPWR _499_/VGND sky130_fd_sc_hd__dfxtp_1
X_251_ _504_/VGND _474_/VPWR _251_/X _251_/B _251_/A _251_/C _252_/VPB VSUBS sky130_fd_sc_hd__and3_1
X_303_ _303_/VPB VSUBS _489_/VGND _426_/VPWR _303_/A _303_/B _303_/Y _303_/C sky130_fd_sc_hd__nand3_1
Xclkload5 VSUBS _483_/VPB _492_/VPWR _435_/VGND clkload5/A clkload5/Y sky130_fd_sc_hd__clkinv_2
X_234_ _234_/VPB VSUBS _448_/VGND _499_/VPWR _234_/C _234_/B _234_/A _234_/Y sky130_fd_sc_hd__nor3_1
X_482_ _482_/Q _482_/CLK _482_/D _484_/VPB VSUBS _493_/VPWR _493_/VGND sky130_fd_sc_hd__dfxtp_1
X_396_ _396_/VPB VSUBS _504_/VGND _474_/VPWR _396_/C _396_/B _396_/A _396_/Y sky130_fd_sc_hd__nor3_1
X_465_ _465_/Q _465_/CLK _465_/D _465_/VPB VSUBS _505_/VPWR _504_/VGND sky130_fd_sc_hd__dfxtp_1
X_302_ _454_/VPB VSUBS _491_/VGND _459_/VPWR _302_/C_N _302_/B _302_/Y _302_/A sky130_fd_sc_hd__nor3b_1
Xclkload6 clkload6/X clkload6/A _431_/VPB VSUBS _435_/VGND _492_/VPWR sky130_fd_sc_hd__clkbuf_8
X_448_ _448_/Q _448_/CLK _448_/D _461_/VPB VSUBS _496_/VPWR _448_/VGND sky130_fd_sc_hd__dfxtp_1
X_233_ _499_/VGND _499_/VPWR _233_/X _233_/B _233_/A _233_/C _234_/VPB VSUBS sky130_fd_sc_hd__and3_1
X_379_ _382_/VPB VSUBS _507_/VGND _506_/VPWR _379_/A _379_/B _379_/Y _379_/C sky130_fd_sc_hd__nand3_1
X_250_ _474_/VPWR _504_/VGND _252_/VPB VSUBS _250_/A2 _250_/A1 _250_/B1 _250_/Y sky130_fd_sc_hd__a21oi_1
X_481_ _481_/Q _481_/CLK _481_/D _481_/VPB VSUBS _499_/VPWR _499_/VGND sky130_fd_sc_hd__dfxtp_1
Xclkbuf_3_2__f_clk clkbuf_3_2__f_clk/X clkbuf_3_2__f_clk/A _485_/VPB VSUBS _435_/VGND
+ _493_/VPWR sky130_fd_sc_hd__clkbuf_8
X_464_ _464_/Q _464_/CLK _464_/D _496_/VPB VSUBS _496_/VPWR _496_/VGND sky130_fd_sc_hd__dfxtp_1
X_447_ _447_/Q _447_/CLK _447_/D _505_/VPB VSUBS _505_/VPWR _505_/VGND sky130_fd_sc_hd__dfxtp_1
X_378_ _473_/VPB VSUBS _507_/VGND _506_/VPWR _378_/C_N _378_/B _378_/Y _378_/A sky130_fd_sc_hd__nor3b_1
X_395_ _504_/VGND _474_/VPWR _395_/X _395_/B _395_/A _395_/C _395_/VPB VSUBS sky130_fd_sc_hd__and3_1
X_301_ _492_/VPWR _492_/VGND _417_/VPB VSUBS _301_/A2 _301_/A1 _301_/B1 _301_/X sky130_fd_sc_hd__a21o_1
X_232_ _499_/VPWR _499_/VGND _234_/VPB VSUBS _232_/A2 _232_/A1 _232_/B1 _232_/Y sky130_fd_sc_hd__a21oi_1
X_463_ _463_/Q _463_/CLK _463_/D _496_/VPB VSUBS _496_/VPWR _496_/VGND sky130_fd_sc_hd__dfxtp_1
X_480_ _480_/Q _480_/CLK _480_/D _480_/VPB VSUBS _505_/VPWR _505_/VGND sky130_fd_sc_hd__dfxtp_1
X_394_ _505_/VPWR _505_/VGND _505_/VPB VSUBS _394_/A2 _394_/A1 _394_/B1 _394_/Y sky130_fd_sc_hd__a21oi_1
X_300_ _492_/VGND _459_/VPWR _415_/VPB VSUBS _300_/A3 _300_/A2 _300_/A1 _300_/Y _300_/B1
+ sky130_fd_sc_hd__a31oi_1
X_231_ _231_/VPB VSUBS _499_/VGND _499_/VPWR _231_/C _231_/B _231_/A _231_/Y sky130_fd_sc_hd__nor3_1
X_446_ _446_/Q _446_/CLK _446_/D _473_/VPB VSUBS _506_/VPWR _507_/VGND sky130_fd_sc_hd__dfxtp_1
X_377_ _506_/VPWR _506_/VGND _473_/VPB VSUBS _377_/A2 _377_/A1 _377_/B1 _377_/X sky130_fd_sc_hd__a21o_1
X_429_ _491_/VPB VSUBS _491_/VGND _491_/VPWR _429_/C _429_/B _429_/A _429_/Y sky130_fd_sc_hd__nor3_1
X_462_ _462_/Q _462_/CLK _462_/D _484_/VPB VSUBS _493_/VPWR _493_/VGND sky130_fd_sc_hd__dfxtp_1
X_393_ _478_/VPB VSUBS _507_/VGND _507_/VPWR _393_/C _393_/B _393_/A _393_/Y sky130_fd_sc_hd__nor3_1
X_428_ _489_/VGND _491_/VPWR _428_/X _428_/B _428_/A _428_/C _491_/VPB VSUBS sky130_fd_sc_hd__and3_1
X_230_ _505_/VGND _500_/VPWR _230_/X _230_/B _230_/A _230_/C _466_/VPB VSUBS sky130_fd_sc_hd__and3_1
X_445_ _445_/Q _445_/CLK _445_/D _445_/VPB VSUBS _502_/VPWR _502_/VGND sky130_fd_sc_hd__dfxtp_1
X_359_ _469_/VPB VSUBS _502_/VGND _507_/VPWR _359_/A _359_/B _359_/Y _359_/C sky130_fd_sc_hd__nand3_1
X_376_ _506_/VGND _506_/VPWR _473_/VPB VSUBS _376_/A3 _376_/A2 _376_/A1 _376_/Y _376_/B1
+ sky130_fd_sc_hd__a31oi_1
X_461_ _461_/Q _461_/CLK _461_/D _461_/VPB VSUBS _496_/VPWR _496_/VGND sky130_fd_sc_hd__dfxtp_1
X_392_ _507_/VGND _506_/VPWR _392_/X _392_/B _392_/A _392_/C _473_/VPB VSUBS sky130_fd_sc_hd__and3_1
X_444_ _444_/Q _444_/CLK _444_/D _444_/VPB VSUBS _507_/VPWR _507_/VGND sky130_fd_sc_hd__dfxtp_1
X_375_ _473_/VPB VSUBS _507_/VGND _506_/VPWR _375_/A _375_/B _375_/Y _375_/C sky130_fd_sc_hd__nand3_1
X_427_ _491_/VPWR _489_/VGND _491_/VPB VSUBS _427_/A2 _427_/A1 _427_/B1 _427_/Y sky130_fd_sc_hd__a21oi_1
X_289_ _493_/VPWR _493_/VGND _484_/VPB VSUBS _289_/A2 _289_/A1 _289_/B1 _289_/X sky130_fd_sc_hd__a21o_1
X_358_ _474_/VPB VSUBS _504_/VGND _474_/VPWR _358_/C_N _358_/B _358_/Y _358_/A sky130_fd_sc_hd__nor3b_1
X_460_ _460_/Q _460_/CLK _460_/D _460_/VPB VSUBS _460_/VPWR _493_/VGND sky130_fd_sc_hd__dfxtp_1
X_391_ _507_/VPWR _507_/VGND _478_/VPB VSUBS _391_/A2 _391_/A1 _391_/B1 _391_/Y sky130_fd_sc_hd__a21oi_1
X_426_ _426_/VPB VSUBS _489_/VGND _426_/VPWR _426_/C _426_/B _426_/A _426_/Y sky130_fd_sc_hd__nor3_1
X_288_ _493_/VGND _460_/VPWR _288_/VPB VSUBS _288_/A3 _288_/A2 _288_/A1 _288_/Y _288_/B1
+ sky130_fd_sc_hd__a31oi_1
X_443_ _496_/VGND _496_/VPWR _443_/X _443_/B _443_/A _443_/C _496_/VPB VSUBS sky130_fd_sc_hd__and3_1
X_357_ _474_/VPWR _506_/VGND _474_/VPB VSUBS _357_/A2 _357_/A1 _357_/B1 _357_/X sky130_fd_sc_hd__a21o_1
X_374_ _374_/VPB VSUBS _504_/VGND _474_/VPWR _374_/C_N _374_/B _374_/Y _374_/A sky130_fd_sc_hd__nor3b_1
X_409_ _460_/VPWR _493_/VGND _409_/VPB VSUBS _409_/A2 _409_/A1 _409_/B1 _409_/Y sky130_fd_sc_hd__a21oi_1
X_390_ _477_/VPB VSUBS _502_/VGND _507_/VPWR _390_/C _390_/B _390_/A _390_/Y sky130_fd_sc_hd__nor3_1
X_442_ _496_/VPWR _448_/VGND _496_/VPB VSUBS _442_/A2 _442_/A1 _442_/B1 _442_/Y sky130_fd_sc_hd__a21oi_1
X_373_ _505_/VPWR _504_/VGND _505_/VPB VSUBS _373_/A2 _373_/A1 _373_/B1 _373_/X sky130_fd_sc_hd__a21o_1
X_425_ _489_/VGND _491_/VPWR _425_/X _425_/B _425_/A _425_/C _491_/VPB VSUBS sky130_fd_sc_hd__and3_1
X_408_ _408_/VPB VSUBS _492_/VGND _459_/VPWR _408_/C _408_/B _408_/A _408_/Y sky130_fd_sc_hd__nor3_1
X_287_ _484_/VPB VSUBS _435_/VGND _493_/VPWR _287_/A _287_/B _287_/Y _287_/C sky130_fd_sc_hd__nand3_1
X_356_ _506_/VGND _474_/VPWR _474_/VPB VSUBS _356_/A3 _356_/A2 _356_/A1 _356_/Y _356_/B1
+ sky130_fd_sc_hd__a31oi_1
X_339_ _339_/VPB VSUBS _448_/VGND _499_/VPWR _339_/A _339_/B _339_/Y _339_/C sky130_fd_sc_hd__nand3_1
X_424_ _491_/VPWR _489_/VGND _491_/VPB VSUBS _424_/A2 _424_/A1 _424_/B1 _424_/Y sky130_fd_sc_hd__a21oi_1
X_286_ _286_/VPB VSUBS _492_/VGND _459_/VPWR _286_/C_N _286_/B _286_/Y _286_/A sky130_fd_sc_hd__nor3b_1
X_441_ _496_/VPB VSUBS _448_/VGND _496_/VPWR _441_/C _441_/B _441_/A _441_/Y sky130_fd_sc_hd__nor3_1
X_355_ _474_/VPB VSUBS _504_/VGND _474_/VPWR _355_/A _355_/B _355_/Y _355_/C sky130_fd_sc_hd__nand3_1
X_372_ _504_/VGND _474_/VPWR _374_/VPB VSUBS _372_/A3 _372_/A2 _372_/A1 _372_/Y _372_/B1
+ sky130_fd_sc_hd__a31oi_1
X_407_ _435_/VGND _492_/VPWR _407_/X _407_/B _407_/A _407_/C _483_/VPB VSUBS sky130_fd_sc_hd__and3_1
Xclkbuf_3_3__f_clk clkbuf_3_3__f_clk/X clkbuf_3_3__f_clk/A _452_/VPB VSUBS _435_/VGND
+ _492_/VPWR sky130_fd_sc_hd__clkbuf_8
X_338_ _496_/VPB VSUBS _448_/VGND _496_/VPWR _338_/C_N _338_/B _338_/Y _338_/A sky130_fd_sc_hd__nor3b_1
X_269_ _506_/VPWR _506_/VGND _473_/VPB VSUBS _269_/A2 _269_/A1 _269_/B1 _269_/X sky130_fd_sc_hd__a21o_1
X_440_ _496_/VGND _496_/VPWR _440_/X _440_/B _440_/A _440_/C _496_/VPB VSUBS sky130_fd_sc_hd__and3_1
X_371_ _505_/VPB VSUBS _505_/VGND _505_/VPWR _371_/A _371_/B _371_/Y _371_/C sky130_fd_sc_hd__nand3_1
X_423_ _489_/VPB VSUBS _491_/VGND _491_/VPWR _423_/C _423_/B _423_/A _423_/Y sky130_fd_sc_hd__nor3_1
X_285_ _493_/VPWR _435_/VGND _484_/VPB VSUBS _285_/A2 _285_/A1 _285_/B1 _285_/X sky130_fd_sc_hd__a21o_1
X_354_ _500_/VPB VSUBS _499_/VGND _500_/VPWR _354_/C_N _354_/B _354_/Y _354_/A sky130_fd_sc_hd__nor3b_1
X_406_ _492_/VPWR _435_/VGND _483_/VPB VSUBS _406_/A2 _406_/A1 _406_/B1 _406_/Y sky130_fd_sc_hd__a21oi_1
X_337_ _496_/VPWR _496_/VGND _496_/VPB VSUBS _337_/A2 _337_/A1 _337_/B1 _337_/X sky130_fd_sc_hd__a21o_1
X_268_ _507_/VGND _506_/VPWR _473_/VPB VSUBS _268_/A3 _268_/A2 _268_/A1 _268_/Y _268_/B1
+ sky130_fd_sc_hd__a31oi_1
X_284_ _492_/VGND _459_/VPWR _286_/VPB VSUBS _284_/A3 _284_/A2 _284_/A1 _284_/Y _284_/B1
+ sky130_fd_sc_hd__a31oi_1
X_422_ _492_/VGND _459_/VPWR _422_/X _422_/B _422_/A _422_/C _456_/VPB VSUBS sky130_fd_sc_hd__and3_1
X_499_ _499_/Q _499_/CLK _499_/D _499_/VPB VSUBS _499_/VPWR _499_/VGND sky130_fd_sc_hd__dfxtp_1
X_353_ _500_/VPWR _499_/VGND _500_/VPB VSUBS _353_/A2 _353_/A1 _353_/B1 _353_/X sky130_fd_sc_hd__a21o_1
X_370_ _370_/VPB VSUBS _506_/VGND _506_/VPWR _370_/C_N _370_/B _370_/Y _370_/A sky130_fd_sc_hd__nor3b_1
X_405_ _484_/VPB VSUBS _435_/VGND _493_/VPWR _405_/C _405_/B _405_/A _405_/Y sky130_fd_sc_hd__nor3_1
X_336_ _496_/VGND _460_/VPWR _409_/VPB VSUBS _336_/A3 _336_/A2 _336_/A1 _336_/Y _336_/B1
+ sky130_fd_sc_hd__a31oi_1
X_267_ _473_/VPB VSUBS _506_/VGND _506_/VPWR _267_/A _267_/B _267_/Y _267_/C sky130_fd_sc_hd__nand3_1
X_319_ _431_/VPB VSUBS _435_/VGND _492_/VPWR _319_/A _319_/B _319_/Y _319_/C sky130_fd_sc_hd__nand3_1
X_421_ _459_/VPWR _491_/VGND _456_/VPB VSUBS _421_/A2 _421_/A1 _421_/B1 _421_/Y sky130_fd_sc_hd__a21oi_1
X_283_ _484_/VPB VSUBS _435_/VGND _493_/VPWR _283_/A _283_/B _283_/Y _283_/C sky130_fd_sc_hd__nand3_1
X_352_ _505_/VGND _500_/VPWR _500_/VPB VSUBS _352_/A3 _352_/A2 _352_/A1 _352_/Y _352_/B1
+ sky130_fd_sc_hd__a31oi_1
X_498_ _498_/Q _498_/CLK _498_/D _504_/VPB VSUBS _505_/VPWR _505_/VGND sky130_fd_sc_hd__dfxtp_1
X_318_ _491_/VPB VSUBS _489_/VGND _491_/VPWR _318_/C_N _318_/B _318_/Y _318_/A sky130_fd_sc_hd__nor3b_1
X_404_ _493_/VGND _460_/VPWR _404_/X _404_/B _404_/A _404_/C _404_/VPB VSUBS sky130_fd_sc_hd__and3_1
X_335_ _496_/VPB VSUBS _448_/VGND _496_/VPWR _335_/A _335_/B _335_/Y _335_/C sky130_fd_sc_hd__nand3_1
X_249_ _505_/VPB VSUBS _505_/VGND _505_/VPWR _249_/C _249_/B _249_/A _249_/Y sky130_fd_sc_hd__nor3_1
X_266_ _445_/VPB VSUBS _502_/VGND _502_/VPWR _266_/C_N _266_/B _266_/Y _266_/A sky130_fd_sc_hd__nor3b_1
X_497_ _497_/Q _497_/CLK _497_/D _497_/VPB VSUBS _499_/VPWR _499_/VGND sky130_fd_sc_hd__dfxtp_1
X_420_ _420_/VPB VSUBS _489_/VGND _426_/VPWR _420_/C _420_/B _420_/A _420_/Y sky130_fd_sc_hd__nor3_1
X_403_ _493_/VPWR _435_/VGND _484_/VPB VSUBS _403_/A2 _403_/A1 _403_/B1 _403_/Y sky130_fd_sc_hd__a21oi_1
X_334_ _496_/VPB VSUBS _496_/VGND _496_/VPWR _334_/C_N _334_/B _334_/Y _334_/A sky130_fd_sc_hd__nor3b_1
X_282_ _282_/VPB VSUBS _499_/VGND _500_/VPWR _282_/C_N _282_/B _282_/Y _282_/A sky130_fd_sc_hd__nor3b_1
X_351_ _500_/VPB VSUBS _499_/VGND _500_/VPWR _351_/A _351_/B _351_/Y _351_/C sky130_fd_sc_hd__nand3_1
X_265_ _502_/VPWR _502_/VGND _389_/VPB VSUBS _265_/A2 _265_/A1 _265_/B1 _265_/X sky130_fd_sc_hd__a21o_1
X_317_ _491_/VPWR _491_/VGND _491_/VPB VSUBS _317_/A2 _317_/A1 _317_/B1 _317_/X sky130_fd_sc_hd__a21o_1
X_248_ _505_/VGND _505_/VPWR _248_/X _248_/B _248_/A _248_/C _505_/VPB VSUBS sky130_fd_sc_hd__and3_1
X_496_ _496_/Q _496_/CLK _496_/D _496_/VPB VSUBS _496_/VPWR _496_/VGND sky130_fd_sc_hd__dfxtp_1
X_281_ _499_/VPWR _499_/VGND _467_/VPB VSUBS _281_/A2 _281_/A1 _281_/B1 _281_/X sky130_fd_sc_hd__a21o_1
X_350_ _466_/VPB VSUBS _505_/VGND _500_/VPWR _350_/C_N _350_/B _350_/Y _350_/A sky130_fd_sc_hd__nor3b_1
X_479_ _479_/Q _479_/CLK _479_/D _480_/VPB VSUBS _505_/VPWR _504_/VGND sky130_fd_sc_hd__dfxtp_1
X_316_ _489_/VGND _491_/VPWR _491_/VPB VSUBS _316_/A3 _316_/A2 _316_/A1 _316_/Y _316_/B1
+ sky130_fd_sc_hd__a31oi_1
X_333_ _496_/VPWR _448_/VGND _496_/VPB VSUBS _333_/A2 _333_/A1 _333_/B1 _333_/X sky130_fd_sc_hd__a21o_1
X_402_ _402_/VPB VSUBS _499_/VGND _500_/VPWR _402_/C _402_/B _402_/A _402_/Y sky130_fd_sc_hd__nor3_1
X_264_ _387_/VGND _502_/VPWR _445_/VPB VSUBS _264_/A3 _264_/A2 _264_/A1 _264_/Y _264_/B1
+ sky130_fd_sc_hd__a31oi_1
X_247_ _474_/VPWR _506_/VGND _374_/VPB VSUBS _247_/A2 _247_/A1 _247_/B1 _247_/Y sky130_fd_sc_hd__a21oi_1
X_495_ _495_/Q _495_/CLK _495_/D _496_/VPB VSUBS _496_/VPWR _496_/VGND sky130_fd_sc_hd__dfxtp_1
X_332_ _496_/VGND _460_/VPWR _332_/VPB VSUBS _332_/A3 _332_/A2 _332_/A1 _332_/Y _332_/B1
+ sky130_fd_sc_hd__a31oi_1
X_280_ _448_/VGND _499_/VPWR _467_/VPB VSUBS _280_/A3 _280_/A2 _280_/A1 _280_/Y _280_/B1
+ sky130_fd_sc_hd__a31oi_1
X_401_ _499_/VGND _499_/VPWR _401_/X _401_/B _401_/A _401_/C _401_/VPB VSUBS sky130_fd_sc_hd__and3_1
X_263_ _389_/VPB VSUBS _387_/VGND _502_/VPWR _263_/A _263_/B _263_/Y _263_/C sky130_fd_sc_hd__nand3_1
X_478_ _478_/Q _478_/CLK _478_/D _478_/VPB VSUBS _507_/VPWR _502_/VGND sky130_fd_sc_hd__dfxtp_1
X_315_ _315_/VPB VSUBS _491_/VGND _459_/VPWR _315_/A _315_/B _315_/Y _315_/C sky130_fd_sc_hd__nand3_1
X_246_ _345_/VPB VSUBS _506_/VGND _474_/VPWR _246_/C _246_/B _246_/A _246_/Y sky130_fd_sc_hd__nor3_1
X_229_ _499_/VPWR _499_/VGND _231_/VPB VSUBS _229_/A2 _229_/A1 _229_/B1 _229_/Y sky130_fd_sc_hd__a21oi_1
Xclkbuf_3_4__f_clk clkbuf_3_4__f_clk/X clkbuf_3_4__f_clk/A _374_/VPB VSUBS _504_/VGND
+ _474_/VPWR sky130_fd_sc_hd__clkbuf_8
X_494_ _494_/Q _494_/CLK _494_/D _496_/VPB VSUBS _496_/VPWR _496_/VGND sky130_fd_sc_hd__dfxtp_1
X_477_ _477_/Q _477_/CLK _477_/D _477_/VPB VSUBS _507_/VPWR _507_/VGND sky130_fd_sc_hd__dfxtp_1
X_331_ _496_/VPB VSUBS _448_/VGND _496_/VPWR _331_/A _331_/B _331_/Y _331_/C sky130_fd_sc_hd__nand3_1
X_400_ _500_/VPWR _499_/VGND _402_/VPB VSUBS _400_/A2 _400_/A1 _400_/B1 _400_/Y sky130_fd_sc_hd__a21oi_1
X_262_ _444_/VPB VSUBS _507_/VGND _507_/VPWR _262_/C_N _262_/B _262_/Y _262_/A sky130_fd_sc_hd__nor3b_1
X_314_ _491_/VPB VSUBS _489_/VGND _491_/VPWR _314_/C_N _314_/B _314_/Y _314_/A sky130_fd_sc_hd__nor3b_1
X_228_ _228_/VPB VSUBS _499_/VGND _500_/VPWR _228_/C _228_/B _228_/A _228_/Y sky130_fd_sc_hd__nor3_1
X_245_ _507_/VGND _506_/VPWR _245_/X _245_/B _245_/A _245_/C _370_/VPB VSUBS sky130_fd_sc_hd__and3_1
X_493_ _493_/Q _493_/CLK _493_/D _493_/VPB VSUBS _493_/VPWR _493_/VGND sky130_fd_sc_hd__dfxtp_1
X_330_ _461_/VPB VSUBS _496_/VGND _496_/VPWR _330_/C_N _330_/B _330_/Y _330_/A sky130_fd_sc_hd__nor3b_1
X_476_ _476_/Q _476_/CLK _476_/D _476_/VPB VSUBS _502_/VPWR _502_/VGND sky130_fd_sc_hd__dfxtp_1
X_261_ _507_/VPWR _502_/VGND _444_/VPB VSUBS _261_/A2 _261_/A1 _261_/B1 _261_/X sky130_fd_sc_hd__a21o_1
X_313_ _491_/VPWR _491_/VGND _491_/VPB VSUBS _313_/A2 _313_/A1 _313_/B1 _313_/X sky130_fd_sc_hd__a21o_1
X_459_ _459_/Q _459_/CLK _459_/D _459_/VPB VSUBS _459_/VPWR _492_/VGND sky130_fd_sc_hd__dfxtp_1
X_244_ _474_/VPWR _506_/VGND _345_/VPB VSUBS _244_/A2 _244_/A1 _244_/B1 _244_/Y sky130_fd_sc_hd__a21oi_1
X_227_ _499_/VGND _500_/VPWR _227_/X _227_/B _227_/A _227_/C _228_/VPB VSUBS sky130_fd_sc_hd__and3_1
X_492_ _492_/Q _492_/CLK _492_/D _492_/VPB VSUBS _492_/VPWR _492_/VGND sky130_fd_sc_hd__dfxtp_1
X_458_ _458_/Q _458_/CLK _458_/D _491_/VPB VSUBS _491_/VPWR _489_/VGND sky130_fd_sc_hd__dfxtp_1
X_475_ _475_/Q _475_/CLK _475_/D _476_/VPB VSUBS _502_/VPWR _502_/VGND sky130_fd_sc_hd__dfxtp_1
X_389_ _502_/VGND _502_/VPWR _389_/X _389_/B _389_/A _389_/C _389_/VPB VSUBS sky130_fd_sc_hd__and3_1
X_260_ _502_/VGND _507_/VPWR _444_/VPB VSUBS _260_/A3 _260_/A2 _260_/A1 _260_/Y _260_/B1
+ sky130_fd_sc_hd__a31oi_1
X_312_ _491_/VGND _491_/VPWR _491_/VPB VSUBS _312_/A3 _312_/A2 _312_/A1 _312_/Y _312_/B1
+ sky130_fd_sc_hd__a31oi_1
X_226_ _500_/VPWR _499_/VGND _228_/VPB VSUBS _226_/A2 _226_/A1 _226_/B1 _226_/Y sky130_fd_sc_hd__a21oi_1
X_243_ _502_/VPB VSUBS _387_/VGND _502_/VPWR _243_/C _243_/B _243_/A _243_/Y sky130_fd_sc_hd__nor3_1
X_491_ _491_/Q _491_/CLK _491_/D _491_/VPB VSUBS _491_/VPWR _491_/VGND sky130_fd_sc_hd__dfxtp_1
X_474_ _474_/Q _474_/CLK _474_/D _474_/VPB VSUBS _474_/VPWR _506_/VGND sky130_fd_sc_hd__dfxtp_1
X_457_ _457_/Q _457_/CLK _457_/D _491_/VPB VSUBS _491_/VPWR _489_/VGND sky130_fd_sc_hd__dfxtp_1
X_311_ _491_/VPB VSUBS _491_/VGND _491_/VPWR _311_/A _311_/B _311_/Y _311_/C sky130_fd_sc_hd__nand3_1
X_242_ _502_/VGND _502_/VPWR _242_/X _242_/B _242_/A _242_/C _502_/VPB VSUBS sky130_fd_sc_hd__and3_1
X_388_ _507_/VPWR _502_/VGND _477_/VPB VSUBS _388_/A2 _388_/A1 _388_/B1 _388_/Y sky130_fd_sc_hd__a21oi_1
X_225_ _496_/VPB VSUBS _448_/VGND _496_/VPWR _225_/C _225_/B _225_/A _225_/Y sky130_fd_sc_hd__nor3_1
X_490_ _490_/Q _490_/CLK _490_/D _491_/VPB VSUBS _491_/VPWR _491_/VGND sky130_fd_sc_hd__dfxtp_1
X_456_ _456_/Q _456_/CLK _456_/D _456_/VPB VSUBS _459_/VPWR _492_/VGND sky130_fd_sc_hd__dfxtp_1
X_387_ _387_/VPB VSUBS _387_/VGND _502_/VPWR _387_/C _387_/B _387_/A _387_/Y sky130_fd_sc_hd__nor3_1
X_473_ _473_/Q _473_/CLK _473_/D _473_/VPB VSUBS _506_/VPWR _506_/VGND sky130_fd_sc_hd__dfxtp_1
X_310_ _456_/VPB VSUBS _492_/VGND _459_/VPWR _310_/C_N _310_/B _310_/Y _310_/A sky130_fd_sc_hd__nor3b_1
X_439_ _496_/VPWR _496_/VGND _496_/VPB VSUBS _439_/A2 _439_/A1 _439_/B1 _439_/Y sky130_fd_sc_hd__a21oi_1
X_224_ _496_/VGND _496_/VPWR _224_/X _224_/B _224_/A _224_/C _496_/VPB VSUBS sky130_fd_sc_hd__and3_1
X_241_ _502_/VPWR _387_/VGND _502_/VPB VSUBS _241_/A2 _241_/A1 _241_/B1 _241_/Y sky130_fd_sc_hd__a21oi_1
X_472_ _472_/Q _472_/CLK _472_/D _472_/VPB VSUBS _505_/VPWR _504_/VGND sky130_fd_sc_hd__dfxtp_1
X_455_ _455_/Q _455_/CLK _455_/D _489_/VPB VSUBS _491_/VPWR _489_/VGND sky130_fd_sc_hd__dfxtp_1
X_386_ _502_/VGND _502_/VPWR _386_/X _386_/B _386_/A _386_/C _387_/VPB VSUBS sky130_fd_sc_hd__and3_1
X_240_ _501_/VPB VSUBS _507_/VGND _506_/VPWR _240_/C _240_/B _240_/A _240_/Y sky130_fd_sc_hd__nor3_1
X_438_ _438_/VPB VSUBS _493_/VGND _460_/VPWR _438_/C _438_/B _438_/A _438_/Y sky130_fd_sc_hd__nor3_1
X_223_ _496_/VPWR _448_/VGND _496_/VPB VSUBS _223_/A2 _223_/A1 _223_/B1 _223_/Y sky130_fd_sc_hd__a21oi_1
X_507_ _507_/Q _507_/CLK _507_/D _507_/VPB VSUBS _507_/VPWR _507_/VGND sky130_fd_sc_hd__dfxtp_1
X_369_ _506_/VPWR _506_/VGND _369_/VPB VSUBS _369_/A2 _369_/A1 _369_/B1 _369_/X sky130_fd_sc_hd__a21o_1
Xclkbuf_3_5__f_clk clkbuf_3_5__f_clk/X clkbuf_3_5__f_clk/A _505_/VPB VSUBS _504_/VGND
+ _505_/VPWR sky130_fd_sc_hd__clkbuf_8
X_454_ _454_/Q _454_/CLK _454_/D _454_/VPB VSUBS _459_/VPWR _492_/VGND sky130_fd_sc_hd__dfxtp_1
X_385_ _502_/VPWR _502_/VGND _387_/VPB VSUBS _385_/A2 _385_/A1 _385_/B1 _385_/Y sky130_fd_sc_hd__a21oi_1
X_471_ _471_/Q _471_/CLK _471_/D _503_/VPB VSUBS _506_/VPWR _506_/VGND sky130_fd_sc_hd__dfxtp_1
X_299_ _415_/VPB VSUBS _492_/VGND _459_/VPWR _299_/A _299_/B _299_/Y _299_/C sky130_fd_sc_hd__nand3_1
X_437_ _496_/VGND _460_/VPWR _437_/X _437_/B _437_/A _437_/C _438_/VPB VSUBS sky130_fd_sc_hd__and3_1
X_368_ _506_/VGND _506_/VPWR _369_/VPB VSUBS _368_/A3 _368_/A2 _368_/A1 _368_/Y _368_/B1
+ sky130_fd_sc_hd__a31oi_1
X_506_ _506_/Q _506_/CLK _506_/D _506_/VPB VSUBS _506_/VPWR _506_/VGND sky130_fd_sc_hd__dfxtp_1
X_222_ _496_/VPB VSUBS _448_/VGND _496_/VPWR _222_/C _222_/B _222_/A _222_/Y sky130_fd_sc_hd__nor3_1
X_470_ _470_/Q _470_/CLK _470_/D _502_/VPB VSUBS _502_/VPWR _502_/VGND sky130_fd_sc_hd__dfxtp_1
X_453_ _453_/Q _453_/CLK _453_/D _485_/VPB VSUBS _493_/VPWR _493_/VGND sky130_fd_sc_hd__dfxtp_1
X_384_ _507_/VPB VSUBS _502_/VGND _507_/VPWR _384_/A _384_/B _384_/Y sky130_fd_sc_hd__nor2_1
X_419_ _489_/VGND _491_/VPWR _419_/X _419_/B _419_/A _419_/C _489_/VPB VSUBS sky130_fd_sc_hd__and3_1
X_298_ _298_/VPB VSUBS _493_/VGND _460_/VPWR _298_/C_N _298_/B _298_/Y _298_/A sky130_fd_sc_hd__nor3b_1
X_436_ _460_/VPWR _496_/VGND _438_/VPB VSUBS _436_/A2 _436_/A1 _436_/B1 _436_/Y sky130_fd_sc_hd__a21oi_1
X_505_ _505_/Q _505_/CLK _505_/D _505_/VPB VSUBS _505_/VPWR _505_/VGND sky130_fd_sc_hd__dfxtp_1
X_367_ _369_/VPB VSUBS _506_/VGND _506_/VPWR _367_/A _367_/B _367_/Y _367_/C sky130_fd_sc_hd__nand3_1
X_452_ _452_/Q _452_/CLK _452_/D _452_/VPB VSUBS _492_/VPWR _492_/VGND sky130_fd_sc_hd__dfxtp_1
X_383_ _476_/VPB VSUBS _387_/VGND _502_/VPWR _383_/A _383_/B _383_/Y _383_/C sky130_fd_sc_hd__nand3_1
X_435_ _435_/VPB VSUBS _435_/VGND _493_/VPWR _435_/C _435_/B _435_/A _435_/Y sky130_fd_sc_hd__nor3_1
X_297_ _493_/VPWR _493_/VGND _485_/VPB VSUBS _297_/A2 _297_/A1 _297_/B1 _297_/X sky130_fd_sc_hd__a21o_1
X_504_ _504_/Q _504_/CLK _504_/D _504_/VPB VSUBS _505_/VPWR _504_/VGND sky130_fd_sc_hd__dfxtp_1
X_366_ _502_/VPB VSUBS _387_/VGND _502_/VPWR _366_/C_N _366_/B _366_/Y _366_/A sky130_fd_sc_hd__nor3b_1
X_418_ _491_/VPWR _491_/VGND _489_/VPB VSUBS _418_/A2 _418_/A1 _418_/B1 _418_/Y sky130_fd_sc_hd__a21oi_1
X_349_ _500_/VPWR _499_/VGND _466_/VPB VSUBS _349_/A2 _349_/A1 _349_/B1 _349_/X sky130_fd_sc_hd__a21o_1
X_451_ _451_/Q _451_/CLK _451_/D _483_/VPB VSUBS _492_/VPWR _492_/VGND sky130_fd_sc_hd__dfxtp_1
X_382_ _382_/VPB VSUBS _506_/VGND _506_/VPWR _382_/C_N _382_/B _382_/Y _382_/A sky130_fd_sc_hd__nor3b_1
X_417_ _417_/VPB VSUBS _435_/VGND _492_/VPWR _417_/C _417_/B _417_/A _417_/Y sky130_fd_sc_hd__nor3_1
X_434_ _493_/VGND _493_/VPWR _434_/X _434_/B _434_/A _434_/C _435_/VPB VSUBS sky130_fd_sc_hd__and3_1
X_296_ _493_/VGND _460_/VPWR _296_/VPB VSUBS _296_/A3 _296_/A2 _296_/A1 _296_/Y _296_/B1
+ sky130_fd_sc_hd__a31oi_1
X_279_ _279_/VPB VSUBS _499_/VGND _500_/VPWR _279_/A _279_/B _279_/Y _279_/C sky130_fd_sc_hd__nand3_1
X_348_ _499_/VGND _500_/VPWR _466_/VPB VSUBS _348_/A3 _348_/A2 _348_/A1 _348_/Y _348_/B1
+ sky130_fd_sc_hd__a31oi_1
X_365_ _502_/VPWR _502_/VGND _502_/VPB VSUBS _365_/A2 _365_/A1 _365_/B1 _365_/X sky130_fd_sc_hd__a21o_1
X_503_ _503_/Q _503_/CLK _503_/D _503_/VPB VSUBS _506_/VPWR _507_/VGND sky130_fd_sc_hd__dfxtp_1
Xclkbuf_3_0__f_clk clkbuf_3_0__f_clk/X clkbuf_3_0__f_clk/A _345_/VPB VSUBS _504_/VGND
+ _474_/VPWR sky130_fd_sc_hd__clkbuf_8
X_450_ _450_/Q _450_/CLK _450_/D _483_/VPB VSUBS _492_/VPWR _492_/VGND sky130_fd_sc_hd__dfxtp_1
X_295_ _485_/VPB VSUBS _435_/VGND _493_/VPWR _295_/A _295_/B _295_/Y _295_/C sky130_fd_sc_hd__nand3_1
X_433_ _493_/VPWR _493_/VGND _435_/VPB VSUBS _433_/A2 _433_/A1 _433_/B1 _433_/Y sky130_fd_sc_hd__a21oi_1
X_364_ _387_/VGND _502_/VPWR _502_/VPB VSUBS _364_/A3 _364_/A2 _364_/A1 _364_/Y _364_/B1
+ sky130_fd_sc_hd__a31oi_1
X_502_ _502_/Q _502_/CLK _502_/D _502_/VPB VSUBS _502_/VPWR _502_/VGND sky130_fd_sc_hd__dfxtp_1
X_381_ _506_/VPWR _507_/VGND _382_/VPB VSUBS _381_/A2 _381_/A1 _381_/B1 _381_/X sky130_fd_sc_hd__a21o_1
X_416_ _492_/VGND _492_/VPWR _416_/X _416_/B _416_/A _416_/C _417_/VPB VSUBS sky130_fd_sc_hd__and3_1
X_278_ _481_/VPB VSUBS _448_/VGND _499_/VPWR _278_/C_N _278_/B _278_/Y _278_/A sky130_fd_sc_hd__nor3b_1
X_347_ _466_/VPB VSUBS _499_/VGND _500_/VPWR _347_/A _347_/B _347_/Y _347_/C sky130_fd_sc_hd__nand3_1
X_380_ _507_/VGND _506_/VPWR _382_/VPB VSUBS _380_/A3 _380_/A2 _380_/A1 _380_/Y _380_/B1
+ sky130_fd_sc_hd__a31oi_1
.ends
