* NGSPICE file created from ldo.ext - technology: sky130A

.subckt dev_nfet_w16_l1 B D S G
X0 S G D B sky130_fd_pr__nfet_01v8 ad=4.64 pd=32.58 as=4.64 ps=32.58 w=16 l=1
C0 S D 0.47384f
C1 D G 0.86832f
C2 S G 0.86832f
C3 S B 1.45724f
C4 D B 1.45724f
.ends

.subckt res_res_high_po_1p41_w1p41_l440p9 B R1 R2
X0 R1 R2 B sky130_fd_pr__res_high_po_1p41 l=440.89999
C0 R2 B 0.66301f
C1 R1 B 0.66301f
.ends

.subckt cap_cap_mim_m3_1_w27p5_l27p5 C2 C1 VSUBS
X0 C1 C2 sky130_fd_pr__cap_mim_m3_1 l=27.5 w=27.5
C0 C2 C1 65.9621f
C1 C2 VSUBS 18.87395f
.ends

.subckt dev_pfet_w60_l0p15 B D S G VSUBS
X0 S G D B sky130_fd_pr__pfet_01v8 ad=17.4 pd=120.58 as=17.4 ps=120.58 w=60 l=0.15
C0 B G 0.23544f
C1 D S 5.14714f
C2 B S 3.16028f
C3 B D 3.16028f
C4 G S 0.7775f
C5 D G 0.7775f
C6 S VSUBS 1.62208f
C7 D VSUBS 1.62208f
C8 B VSUBS 20.3534f
.ends

.subckt dev_nfet_w20_l0p5 B D S G
X0 S G D B sky130_fd_pr__nfet_01v8 ad=5.8 pd=40.58 as=5.8 ps=40.58 w=20 l=0.5
C0 G S 0.71064f
C1 G D 0.71064f
C2 S D 0.9722f
C3 S B 1.66629f
C4 D B 1.66629f
.ends

.subckt dev_pfet_w20_l0p5 B D S G VSUBS
X0 S G D B sky130_fd_pr__pfet_01v8 ad=5.8 pd=40.58 as=5.8 ps=40.58 w=20 l=0.5
C0 B D 1.19086f
C1 S G 0.71064f
C2 B G 0.285f
C3 B S 1.19086f
C4 D G 0.71064f
C5 S D 0.9722f
C6 S VSUBS 0.5282f
C7 D VSUBS 0.5282f
C8 B VSUBS 8.27881f
.ends

.subckt ldo IOVDD VREF VOUT VBIAS VSS
XMtail VSS M2/S VSS VBIAS dev_nfet_w16_l1
XR1 VSS VOUT M1/G res_res_high_po_1p41_w1p41_l440p9
XR2 VSS M1/G VSS res_res_high_po_1p41_w1p41_l440p9
XCc1 VOUT M4/D VSS cap_cap_mim_m3_1_w27p5_l27p5
XCc2 VOUT M4/D VSS cap_cap_mim_m3_1_w27p5_l27p5
XMp10 IOVDD VOUT IOVDD M4/D VSS dev_pfet_w60_l0p15
XMp11 IOVDD VOUT IOVDD M4/D VSS dev_pfet_w60_l0p15
XM1 VSS M4/G M2/S M1/G dev_nfet_w20_l0p5
XM2 VSS M4/D M2/S VREF dev_nfet_w20_l0p5
XM4 IOVDD M4/D IOVDD M4/G VSS dev_pfet_w20_l0p5
XM3 IOVDD M4/G IOVDD M4/G VSS dev_pfet_w20_l0p5
XMp0 IOVDD VOUT IOVDD M4/D VSS dev_pfet_w60_l0p15
XMp1 IOVDD VOUT IOVDD M4/D VSS dev_pfet_w60_l0p15
XMp2 IOVDD VOUT IOVDD M4/D VSS dev_pfet_w60_l0p15
XMp4 IOVDD VOUT IOVDD M4/D VSS dev_pfet_w60_l0p15
XMp3 IOVDD VOUT IOVDD M4/D VSS dev_pfet_w60_l0p15
XMp5 IOVDD VOUT IOVDD M4/D VSS dev_pfet_w60_l0p15
XMp6 IOVDD VOUT IOVDD M4/D VSS dev_pfet_w60_l0p15
XMp7 IOVDD VOUT IOVDD M4/D VSS dev_pfet_w60_l0p15
XMp8 IOVDD VOUT IOVDD M4/D VSS dev_pfet_w60_l0p15
XMp9 IOVDD VOUT IOVDD M4/D VSS dev_pfet_w60_l0p15
C0 VOUT M1/G 1.17295f
C1 VREF M4/D 11.77933f
C2 IOVDD M2/S 2.31844f
C3 VREF M4/G 0.08026f
C4 VBIAS M4/D 1.20606f
C5 VREF VOUT 1.12751f
C6 VBIAS M4/G 0.29399f
C7 VREF M1/G 0.08083f
C8 VOUT VBIAS 1.09214f
C9 M4/D M2/S 1.39248f
C10 M1/G VBIAS 0.23517f
C11 M4/G M2/S 0.4078f
C12 VOUT M2/S 1.18788f
C13 M1/G M2/S 3.04333f
C14 VREF VBIAS 0.07959f
C15 VREF M2/S 2.87048f
C16 IOVDD M4/D 45.07431f
C17 IOVDD M4/G 14.17432f
C18 VBIAS M2/S 11.39707f
C19 VOUT IOVDD 91.74347f
C20 M1/G IOVDD 2.16434f
C21 M4/D M4/G 4.06247f
C22 VOUT M4/D 36.94053f
C23 M1/G M4/D 10.018f
C24 VREF IOVDD 11.0071f
C25 VOUT M4/G 1.09195f
C26 M1/G M4/G 11.88672f
C27 VBIAS IOVDD 2.14913f
C28 VBIAS VSS 24.79556f
C29 VREF VSS 13.50053f
C30 VOUT VSS 0.11415p
C31 IOVDD VSS 0.322p
C32 M4/D VSS 0.12541p
C33 M4/G VSS 45.68524f
C34 M1/G VSS 29.29338f
C35 M2/S VSS 53.00503f
.ends
