* ldo -- LVS schematic view (physical primitives)
.subckt ldo IOVDD VSS VREF VOUT VBIAS
XMtail ntail VBIAS VSS VSS sky130_fd_pr__nfet_01v8 W=4 L=1 m=4
XM1 nd1 FB   ntail VSS sky130_fd_pr__nfet_01v8 W=5 L=0.5 m=4
XM2 nd2 VREF ntail VSS sky130_fd_pr__nfet_01v8 W=5 L=0.5 m=4
XM3 nd1 nd1 IOVDD IOVDD sky130_fd_pr__pfet_01v8 W=5 L=0.5 m=4
XM4 nd2 nd1 IOVDD IOVDD sky130_fd_pr__pfet_01v8 W=5 L=0.5 m=4
XMp VOUT nd2 IOVDD IOVDD sky130_fd_pr__pfet_01v8 W=6 L=0.15 m=120
XCc1 nd2 VOUT sky130_fd_pr__cap_mim_m3_1 W=27.5 L=27.5
XCc2 nd2 VOUT sky130_fd_pr__cap_mim_m3_1 W=27.5 L=27.5
XR1 VOUT FB  VSS sky130_fd_pr__res_high_po_1p41 L=440.9
XR2 FB   VSS VSS sky130_fd_pr__res_high_po_1p41 L=440.9
.ends ldo
