* NGSPICE file created from ldo.ext - technology: sky130A

.subckt dev_nfet_w16_l1 B D S G
X0 S G D B sky130_fd_pr__nfet_01v8 ad=4.64 pd=32.58 as=4.64 ps=32.58 w=16 l=1
.ends

.subckt res_res_high_po_1p41_w1p41_l440p9 B R1 R2
X0 R1 R2 B sky130_fd_pr__res_high_po_1p41 l=440.89999
.ends

.subckt cap_cap_mim_m3_1_w27p5_l27p5 C2 C1 VSUBS
X0 C1 C2 sky130_fd_pr__cap_mim_m3_1 l=27.5 w=27.5
.ends

.subckt dev_pfet_w60_l0p15 B D S G VSUBS
X0 S G D B sky130_fd_pr__pfet_01v8 ad=17.4 pd=120.58 as=17.4 ps=120.58 w=60 l=0.15
.ends

.subckt dev_nfet_w20_l0p5 B D S G
X0 S G D B sky130_fd_pr__nfet_01v8 ad=5.8 pd=40.58 as=5.8 ps=40.58 w=20 l=0.5
.ends

.subckt dev_pfet_w20_l0p5 B D S G VSUBS
X0 S G D B sky130_fd_pr__pfet_01v8 ad=5.8 pd=40.58 as=5.8 ps=40.58 w=20 l=0.5
.ends

.subckt ldo IOVDD VREF VOUT VBIAS VSS
XMtail VSS M2/S VSS VBIAS dev_nfet_w16_l1
XR1 VSS VOUT M1/G res_res_high_po_1p41_w1p41_l440p9
XR2 VSS M1/G VSS res_res_high_po_1p41_w1p41_l440p9
XCc1 VOUT M4/D VSS cap_cap_mim_m3_1_w27p5_l27p5
XCc2 VOUT M4/D VSS cap_cap_mim_m3_1_w27p5_l27p5
XMp10 IOVDD VOUT IOVDD M4/D VSS dev_pfet_w60_l0p15
XMp11 IOVDD VOUT IOVDD M4/D VSS dev_pfet_w60_l0p15
XM1 VSS M4/G M2/S M1/G dev_nfet_w20_l0p5
XM2 VSS M4/D M2/S VREF dev_nfet_w20_l0p5
XM4 IOVDD M4/D IOVDD M4/G VSS dev_pfet_w20_l0p5
XM3 IOVDD M4/G IOVDD M4/G VSS dev_pfet_w20_l0p5
XMp0 IOVDD VOUT IOVDD M4/D VSS dev_pfet_w60_l0p15
XMp1 IOVDD VOUT IOVDD M4/D VSS dev_pfet_w60_l0p15
XMp2 IOVDD VOUT IOVDD M4/D VSS dev_pfet_w60_l0p15
XMp4 IOVDD VOUT IOVDD M4/D VSS dev_pfet_w60_l0p15
XMp3 IOVDD VOUT IOVDD M4/D VSS dev_pfet_w60_l0p15
XMp5 IOVDD VOUT IOVDD M4/D VSS dev_pfet_w60_l0p15
XMp6 IOVDD VOUT IOVDD M4/D VSS dev_pfet_w60_l0p15
XMp7 IOVDD VOUT IOVDD M4/D VSS dev_pfet_w60_l0p15
XMp8 IOVDD VOUT IOVDD M4/D VSS dev_pfet_w60_l0p15
XMp9 IOVDD VOUT IOVDD M4/D VSS dev_pfet_w60_l0p15
.ends
