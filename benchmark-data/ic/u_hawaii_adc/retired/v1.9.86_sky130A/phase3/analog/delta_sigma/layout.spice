* NGSPICE file created from ds_ota.ext - technology: sky130A

.subckt dev_nfet_w16_l1 B D S G
X0 S G D B sky130_fd_pr__nfet_01v8 ad=4.64 pd=32.58 as=4.64 ps=32.58 w=16 l=1
.ends

.subckt dev_nfet_w32_l2 B D S G
X0 S G D B sky130_fd_pr__nfet_01v8 ad=9.28 pd=64.58 as=9.28 ps=64.58 w=32 l=2
.ends

.subckt dev_pfet_w32_l2 B D S G VSUBS
X0 S G D B sky130_fd_pr__pfet_01v8 ad=9.28 pd=64.58 as=9.28 ps=64.58 w=32 l=2
.ends

.subckt ds_ota VDD VINP VINN VOUTA VBIAS VSS
XMtail VSS M2/S VSS VBIAS dev_nfet_w16_l1
XM1 VSS M4/G M2/S VINP dev_nfet_w32_l2
XM2 VSS VOUTA M2/S VINN dev_nfet_w32_l2
XM3 VDD M4/G VDD M4/G VSS dev_pfet_w32_l2
XM4 VDD VOUTA VDD M4/G VSS dev_pfet_w32_l2
.ends
