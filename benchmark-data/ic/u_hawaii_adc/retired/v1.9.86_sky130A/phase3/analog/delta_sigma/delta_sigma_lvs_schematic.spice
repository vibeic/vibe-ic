* u_hawaii_adc -- delta_sigma modulator CORE (integrator OTA) -- sky130A retarget (real sky130_fd_pr devices, native ngspice)
* NOTE: L19 tapeout target is IHP SG13G2 (no public ngspice models). This deck
*   is the DISCLOSED open-source sky130A substitute exercising the real ngspice
*   path. The SC switches/caps + decimation are discrete-time/digital and are
*   verified by the behavioral mixed-signal cosim (A9), not this DC/AC deck.
* Analog core: single-stage NMOS-input OTA, long-L for DC-gain margin vs OSR=256
*   integrator-leakage floor (gain >= 20*log10(256) = 48.16 dB).
.subckt ds_ota VDD VSS VINP VINN VOUTA VBIAS
* NMOS tail current source
XMtail ntail VBIAS VSS VSS sky130_fd_pr__nfet_01v8 W=4 L=1 m=4
* NMOS input diff pair (long L -> high ro -> high DC gain)
XM1 nd1 VINP ntail VSS sky130_fd_pr__nfet_01v8 W=8 L=2 m=4
XM2 VOUTA VINN ntail VSS sky130_fd_pr__nfet_01v8 W=8 L=2 m=4
* PMOS mirror load (diode at nd1), long L
XM3 nd1  nd1 VDD VDD sky130_fd_pr__pfet_01v8 W=8 L=2 m=4
XM4 VOUTA nd1 VDD VDD sky130_fd_pr__pfet_01v8 W=8 L=2 m=4
.ends ds_ota
