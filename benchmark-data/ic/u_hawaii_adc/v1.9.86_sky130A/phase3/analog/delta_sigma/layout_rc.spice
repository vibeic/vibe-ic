* NGSPICE file created from ds_ota.ext - technology: sky130A

.subckt dev_nfet_w16_l1 B D S G
X0 S G D B sky130_fd_pr__nfet_01v8 ad=4.64 pd=32.58 as=4.64 ps=32.58 w=16 l=1
C0 S D 0.47384f
C1 G D 0.86832f
C2 S G 0.86832f
C3 S B 1.45724f
C4 D B 1.45724f
.ends

.subckt dev_nfet_w32_l2 B D S G
X0 S G D B sky130_fd_pr__nfet_01v8 ad=9.28 pd=64.58 as=9.28 ps=64.58 w=32 l=2
C0 S G 2.26669f
C1 S D 0.52066f
C2 G D 2.26669f
C3 S B 2.78941f
C4 D B 2.78941f
.ends

.subckt dev_pfet_w32_l2 B D S G VSUBS
X0 S G D B sky130_fd_pr__pfet_01v8 ad=9.28 pd=64.58 as=9.28 ps=64.58 w=32 l=2
C0 S D 0.52066f
C1 S G 2.26669f
C2 B D 2.36524f
C3 B G 0.8206f
C4 D G 2.26669f
C5 S B 2.36524f
C6 S VSUBS 0.80612f
C7 D VSUBS 0.80612f
C8 B VSUBS 18.9394f
.ends

.subckt ds_ota VDD VINP VINN VOUTA VBIAS VSS
XMtail VSS M2/S VSS VBIAS dev_nfet_w16_l1
XM1 VSS M4/G M2/S VINP dev_nfet_w32_l2
XM2 VSS VOUTA M2/S VINN dev_nfet_w32_l2
XM3 VDD M4/G VDD M4/G VSS dev_pfet_w32_l2
XM4 VDD VOUTA VDD M4/G VSS dev_pfet_w32_l2
C0 VBIAS VINP 0.08187f
C1 VDD VINN 2.23121f
C2 VINN M2/S 0.32739f
C3 VINN VOUTA 2.27293f
C4 VINN M4/G 0.08165f
C5 VINN VINP 0.08141f
C6 VINN VBIAS 0.08172f
C7 VDD M2/S 0.36811f
C8 VDD VOUTA 1.46924f
C9 M2/S VOUTA 0.24943f
C10 VDD M4/G 2.24083f
C11 VDD VINP 0.32196f
C12 M2/S M4/G 0.4611f
C13 M4/G VOUTA 0.41813f
C14 VDD VBIAS 0.31143f
C15 VINP M2/S 0.32771f
C16 VINP VOUTA 2.05483f
C17 VBIAS M2/S 2.19279f
C18 VBIAS VOUTA 0.14453f
C19 VINP M4/G 2.24877f
C20 VBIAS M4/G 0.30393f
C21 VBIAS VSS 2.86526f
C22 VINN VSS 2.23448f
C23 VINP VSS 2.04168f
C24 VDD VSS 8.7196f
C25 VOUTA VSS 3.20611f
C26 M4/G VSS 5.88284f
C27 M2/S VSS 3.16032f
.ends
