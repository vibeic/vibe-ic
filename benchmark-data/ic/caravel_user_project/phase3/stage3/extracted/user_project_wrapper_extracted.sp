* NGSPICE file created from user_project_wrapper.ext - technology: sky130A

* Black-box entry subcircuit for sky130_fd_sc_hd__diode_2 abstract view
.subckt sky130_fd_sc_hd__diode_2 DIODE VGND VNB VPB VPWR
.ends

* Black-box entry subcircuit for sky130_fd_sc_hd__nor3b_1 abstract view
.subckt sky130_fd_sc_hd__nor3b_1 A B C_N VGND VNB VPB VPWR Y
.ends

* Black-box entry subcircuit for sky130_fd_sc_hd__conb_1 abstract view
.subckt sky130_fd_sc_hd__conb_1 VGND VNB VPB VPWR HI LO
.ends

* Black-box entry subcircuit for sky130_fd_sc_hd__dfxtp_1 abstract view
.subckt sky130_fd_sc_hd__dfxtp_1 CLK D VGND VNB VPB VPWR Q
.ends

* Black-box entry subcircuit for sky130_fd_sc_hd__nor2_1 abstract view
.subckt sky130_fd_sc_hd__nor2_1 A B VGND VNB VPB VPWR Y
.ends

* Black-box entry subcircuit for sky130_fd_sc_hd__edfxtp_1 abstract view
.subckt sky130_fd_sc_hd__edfxtp_1 CLK D DE VGND VNB VPB VPWR Q
.ends

* Black-box entry subcircuit for sky130_fd_sc_hd__a21oi_1 abstract view
.subckt sky130_fd_sc_hd__a21oi_1 A1 A2 B1 VGND VNB VPB VPWR Y
.ends

* Black-box entry subcircuit for sky130_fd_sc_hd__o21bai_1 abstract view
.subckt sky130_fd_sc_hd__o21bai_1 A1 A2 B1_N VGND VNB VPB VPWR Y
.ends

* Black-box entry subcircuit for sky130_fd_sc_hd__o221ai_1 abstract view
.subckt sky130_fd_sc_hd__o221ai_1 A1 A2 B1 B2 C1 VGND VNB VPB VPWR Y
.ends

* Black-box entry subcircuit for sky130_fd_sc_hd__o21ai_0 abstract view
.subckt sky130_fd_sc_hd__o21ai_0 A1 A2 B1 VGND VNB VPB VPWR Y
.ends

* Black-box entry subcircuit for sky130_fd_sc_hd__nand2_1 abstract view
.subckt sky130_fd_sc_hd__nand2_1 A B VGND VNB VPB VPWR Y
.ends

* Black-box entry subcircuit for sky130_fd_sc_hd__dfxtp_2 abstract view
.subckt sky130_fd_sc_hd__dfxtp_2 CLK D VGND VNB VPB VPWR Q
.ends

* Black-box entry subcircuit for sky130_fd_sc_hd__inv_1 abstract view
.subckt sky130_fd_sc_hd__inv_1 A VGND VNB VPB VPWR Y
.ends

* Black-box entry subcircuit for sky130_fd_sc_hd__clkbuf_16 abstract view
.subckt sky130_fd_sc_hd__clkbuf_16 A VGND VNB VPB VPWR X
.ends

* Black-box entry subcircuit for sky130_fd_sc_hd__bufinv_16 abstract view
.subckt sky130_fd_sc_hd__bufinv_16 A VGND VNB VPB VPWR Y
.ends

* Black-box entry subcircuit for sky130_fd_sc_hd__o22a_1 abstract view
.subckt sky130_fd_sc_hd__o22a_1 A1 A2 B1 B2 VGND VNB VPB VPWR X
.ends

* Black-box entry subcircuit for sky130_fd_sc_hd__a31oi_1 abstract view
.subckt sky130_fd_sc_hd__a31oi_1 A1 A2 A3 B1 VGND VNB VPB VPWR Y
.ends

* Black-box entry subcircuit for sky130_fd_sc_hd__nor3_1 abstract view
.subckt sky130_fd_sc_hd__nor3_1 A B C VGND VNB VPB VPWR Y
.ends

* Black-box entry subcircuit for sky130_fd_sc_hd__inv_6 abstract view
.subckt sky130_fd_sc_hd__inv_6 A VGND VNB VPB VPWR Y
.ends

* Black-box entry subcircuit for sky130_fd_sc_hd__mux2_1 abstract view
.subckt sky130_fd_sc_hd__mux2_1 A0 A1 S VGND VNB VPB VPWR X
.ends

* Black-box entry subcircuit for sky130_fd_sc_hd__a211oi_1 abstract view
.subckt sky130_fd_sc_hd__a211oi_1 A1 A2 B1 C1 VGND VNB VPB VPWR Y
.ends

* Black-box entry subcircuit for sky130_fd_sc_hd__clkbuf_1 abstract view
.subckt sky130_fd_sc_hd__clkbuf_1 A VGND VNB VPB VPWR X
.ends

* Black-box entry subcircuit for sky130_fd_sc_hd__nand3_1 abstract view
.subckt sky130_fd_sc_hd__nand3_1 A B C VGND VNB VPB VPWR Y
.ends

* Black-box entry subcircuit for sky130_fd_sc_hd__nor4_1 abstract view
.subckt sky130_fd_sc_hd__nor4_1 A B C D VGND VNB VPB VPWR Y
.ends

* Black-box entry subcircuit for sky130_fd_sc_hd__a311oi_1 abstract view
.subckt sky130_fd_sc_hd__a311oi_1 A1 A2 A3 B1 C1 VGND VNB VPB VPWR Y
.ends

* Black-box entry subcircuit for sky130_fd_sc_hd__nand2b_1 abstract view
.subckt sky130_fd_sc_hd__nand2b_1 A_N B VGND VNB VPB VPWR Y
.ends

* Black-box entry subcircuit for sky130_fd_sc_hd__a22oi_1 abstract view
.subckt sky130_fd_sc_hd__a22oi_1 A1 A2 B1 B2 VGND VNB VPB VPWR Y
.ends

* Black-box entry subcircuit for sky130_fd_sc_hd__a41oi_1 abstract view
.subckt sky130_fd_sc_hd__a41oi_1 A1 A2 A3 A4 B1 VGND VNB VPB VPWR Y
.ends

* Black-box entry subcircuit for sky130_fd_sc_hd__lpflow_isobufsrc_1 abstract view
.subckt sky130_fd_sc_hd__lpflow_isobufsrc_1 A SLEEP VGND VNB VPB VPWR X
.ends

* Black-box entry subcircuit for sky130_fd_sc_hd__and2_0 abstract view
.subckt sky130_fd_sc_hd__and2_0 A B VGND VNB VPB VPWR X
.ends

* Black-box entry subcircuit for sky130_fd_sc_hd__dfrtp_1 abstract view
.subckt sky130_fd_sc_hd__dfrtp_1 CLK D RESET_B VGND VNB VPB VPWR Q
.ends

* Black-box entry subcircuit for sky130_fd_sc_hd__a32oi_1 abstract view
.subckt sky130_fd_sc_hd__a32oi_1 A1 A2 A3 B1 B2 VGND VNB VPB VPWR Y
.ends

* Black-box entry subcircuit for sky130_fd_sc_hd__and4_1 abstract view
.subckt sky130_fd_sc_hd__and4_1 A B C D VGND VNB VPB VPWR X
.ends

* Black-box entry subcircuit for sky130_fd_sc_hd__mux2_2 abstract view
.subckt sky130_fd_sc_hd__mux2_2 A0 A1 S VGND VNB VPB VPWR X
.ends

* Black-box entry subcircuit for sky130_fd_sc_hd__and3_1 abstract view
.subckt sky130_fd_sc_hd__and3_1 A B C VGND VNB VPB VPWR X
.ends

* Black-box entry subcircuit for sky130_fd_sc_hd__nand2_2 abstract view
.subckt sky130_fd_sc_hd__nand2_2 A B VGND VNB VPB VPWR Y
.ends

* Black-box entry subcircuit for sky130_fd_sc_hd__a41o_1 abstract view
.subckt sky130_fd_sc_hd__a41o_1 A1 A2 A3 A4 B1 VGND VNB VPB VPWR X
.ends

* Black-box entry subcircuit for sky130_fd_sc_hd__a21oi_2 abstract view
.subckt sky130_fd_sc_hd__a21oi_2 A1 A2 B1 VGND VNB VPB VPWR Y
.ends

* Black-box entry subcircuit for sky130_fd_sc_hd__buf_12 abstract view
.subckt sky130_fd_sc_hd__buf_12 A VGND VNB VPB VPWR X
.ends

* Black-box entry subcircuit for sky130_fd_sc_hd__a221oi_1 abstract view
.subckt sky130_fd_sc_hd__a221oi_1 A1 A2 B1 B2 C1 VGND VNB VPB VPWR Y
.ends

* Black-box entry subcircuit for sky130_fd_sc_hd__or3_1 abstract view
.subckt sky130_fd_sc_hd__or3_1 A B C VGND VNB VPB VPWR X
.ends

* Black-box entry subcircuit for sky130_fd_sc_hd__nor2_2 abstract view
.subckt sky130_fd_sc_hd__nor2_2 A B VGND VNB VPB VPWR Y
.ends

.subckt user_project_wrapper analog_io[0] analog_io[10] analog_io[11] analog_io[12] analog_io[13] analog_io[14] analog_io[15] analog_io[16] analog_io[17] analog_io[18] analog_io[19] analog_io[1] analog_io[20] analog_io[21] analog_io[22] analog_io[23] analog_io[24] analog_io[25] analog_io[26] analog_io[27] analog_io[28] analog_io[2] analog_io[3] analog_io[4] analog_io[5] analog_io[6] analog_io[7] analog_io[8] analog_io[9] io_in[0] io_in[10] io_in[11] io_in[12] io_in[13] io_in[14] io_in[15] io_in[16] io_in[17] io_in[18] io_in[19] io_in[1] io_in[20] io_in[21] io_in[22] io_in[23] io_in[24] io_in[25] io_in[26] io_in[27] io_in[28] io_in[29] io_in[2] io_in[30] io_in[31] io_in[32] io_in[33] io_in[34] io_in[35] io_in[36] io_in[37] io_in[3] io_in[4] io_in[5] io_in[6] io_in[7] io_in[8] io_in[9] io_oeb[7] io_out[0] io_out[1] io_out[2] io_out[30] io_out[31] io_out[32] io_out[33] io_out[34] io_out[35] io_out[36] io_out[37] io_out[3] io_out[4] io_out[5] io_out[6] io_out[7] io_out[9] la_data_in[0] la_data_in[100] la_data_in[101] la_data_in[102] la_data_in[103] la_data_in[104] la_data_in[105] la_data_in[106] la_data_in[107] la_data_in[108] la_data_in[109] la_data_in[10] la_data_in[110] la_data_in[111] la_data_in[112] la_data_in[113] la_data_in[114] la_data_in[115] la_data_in[116] la_data_in[117] la_data_in[118] la_data_in[119] la_data_in[11] la_data_in[120] la_data_in[121] la_data_in[122] la_data_in[123] la_data_in[124] la_data_in[125] la_data_in[126] la_data_in[127] la_data_in[12] la_data_in[13] la_data_in[14] la_data_in[15] la_data_in[16] la_data_in[17] la_data_in[18] la_data_in[19] la_data_in[1] la_data_in[20] la_data_in[21] la_data_in[22] la_data_in[23] la_data_in[24] la_data_in[25] la_data_in[26] la_data_in[27] la_data_in[28] la_data_in[29] la_data_in[2] la_data_in[30] la_data_in[31] la_data_in[32] la_data_in[33] la_data_in[34] la_data_in[35] la_data_in[36] la_data_in[37] la_data_in[38] la_data_in[39] la_data_in[3] la_data_in[40] la_data_in[41] la_data_in[42] la_data_in[43] la_data_in[44] la_data_in[45] la_data_in[46] la_data_in[47] la_data_in[48] la_data_in[49] la_data_in[4] la_data_in[50] la_data_in[51] la_data_in[52] la_data_in[53] la_data_in[54] la_data_in[55] la_data_in[56] la_data_in[57] la_data_in[58] la_data_in[59] la_data_in[5] la_data_in[60] la_data_in[61] la_data_in[62] la_data_in[63] la_data_in[64] la_data_in[65] la_data_in[66] la_data_in[67] la_data_in[68] la_data_in[69] la_data_in[6] la_data_in[70] la_data_in[71] la_data_in[72] la_data_in[73] la_data_in[74] la_data_in[75] la_data_in[76] la_data_in[77] la_data_in[78] la_data_in[79] la_data_in[7] la_data_in[80] la_data_in[81] la_data_in[82] la_data_in[83] la_data_in[84] la_data_in[85] la_data_in[86] la_data_in[87] la_data_in[88] la_data_in[89] la_data_in[8] la_data_in[90] la_data_in[91] la_data_in[92] la_data_in[93] la_data_in[94] la_data_in[95] la_data_in[96] la_data_in[97] la_data_in[98] la_data_in[99] la_data_in[9] la_data_out[100] la_data_out[101] la_data_out[102] la_data_out[103] la_data_out[104] la_data_out[105] la_data_out[106] la_data_out[107] la_data_out[108] la_data_out[109] la_data_out[110] la_data_out[111] la_data_out[112] la_data_out[113] la_data_out[114] la_data_out[115] la_data_out[116] la_data_out[117] la_data_out[118] la_data_out[119] la_data_out[120] la_data_out[121] la_data_out[122] la_data_out[123] la_data_out[124] la_data_out[125] la_data_out[126] la_data_out[127] la_data_out[16] la_data_out[17] la_data_out[18] la_data_out[19] la_data_out[20] la_data_out[21] la_data_out[22] la_data_out[23] la_data_out[24] la_data_out[25] la_data_out[26] la_data_out[27] la_data_out[28] la_data_out[29] la_data_out[30] la_data_out[31] la_data_out[32] la_data_out[33] la_data_out[34] la_data_out[35] la_data_out[36] la_data_out[37] la_data_out[38] la_data_out[39] la_data_out[40] la_data_out[41] la_data_out[42] la_data_out[43] la_data_out[44] la_data_out[45] la_data_out[46] la_data_out[47] la_data_out[48] la_data_out[49] la_data_out[50] la_data_out[51] la_data_out[52] la_data_out[53] la_data_out[54] la_data_out[55] la_data_out[56] la_data_out[57] la_data_out[58] la_data_out[59] la_data_out[60] la_data_out[61] la_data_out[62] la_data_out[63] la_data_out[64] la_data_out[65] la_data_out[66] la_data_out[67] la_data_out[68] la_data_out[69] la_data_out[70] la_data_out[71] la_data_out[72] la_data_out[73] la_data_out[74] la_data_out[75] la_data_out[76] la_data_out[77] la_data_out[78] la_data_out[79] la_data_out[80] la_data_out[81] la_data_out[82] la_data_out[83] la_data_out[84] la_data_out[85] la_data_out[86] la_data_out[87] la_data_out[88] la_data_out[89] la_data_out[90] la_data_out[91] la_data_out[92] la_data_out[93] la_data_out[94] la_data_out[95] la_data_out[96] la_data_out[97] la_data_out[98] la_data_out[99] la_oenb[0] la_oenb[100] la_oenb[101] la_oenb[102] la_oenb[103] la_oenb[104] la_oenb[105] la_oenb[106] la_oenb[107] la_oenb[108] la_oenb[109] la_oenb[10] la_oenb[110] la_oenb[111] la_oenb[112] la_oenb[113] la_oenb[114] la_oenb[115] la_oenb[116] la_oenb[117] la_oenb[118] la_oenb[119] la_oenb[11] la_oenb[120] la_oenb[121] la_oenb[122] la_oenb[123] la_oenb[124] la_oenb[125] la_oenb[126] la_oenb[127] la_oenb[12] la_oenb[13] la_oenb[14] la_oenb[15] la_oenb[16] la_oenb[17] la_oenb[18] la_oenb[19] la_oenb[1] la_oenb[20] la_oenb[21] la_oenb[22] la_oenb[23] la_oenb[24] la_oenb[25] la_oenb[26] la_oenb[27] la_oenb[28] la_oenb[29] la_oenb[2] la_oenb[30] la_oenb[31] la_oenb[32] la_oenb[33] la_oenb[34] la_oenb[35] la_oenb[36] la_oenb[37] la_oenb[38] la_oenb[39] la_oenb[3] la_oenb[40] la_oenb[41] la_oenb[42] la_oenb[43] la_oenb[44] la_oenb[45] la_oenb[46] la_oenb[47] la_oenb[48] la_oenb[49] la_oenb[4] la_oenb[50] la_oenb[51] la_oenb[52] la_oenb[53] la_oenb[54] la_oenb[55] la_oenb[56] la_oenb[57] la_oenb[58] la_oenb[59] la_oenb[5] la_oenb[60] la_oenb[61] la_oenb[62] la_oenb[63] la_oenb[64] la_oenb[65] la_oenb[66] la_oenb[67] la_oenb[68] la_oenb[69] la_oenb[6] la_oenb[70] la_oenb[71] la_oenb[72] la_oenb[73] la_oenb[74] la_oenb[75] la_oenb[76] la_oenb[77] la_oenb[78] la_oenb[79] la_oenb[7] la_oenb[80] la_oenb[81] la_oenb[82] la_oenb[83] la_oenb[84] la_oenb[85] la_oenb[86] la_oenb[87] la_oenb[88] la_oenb[89] la_oenb[8] la_oenb[90] la_oenb[91] la_oenb[92] la_oenb[93] la_oenb[94] la_oenb[95] la_oenb[96] la_oenb[97] la_oenb[98] la_oenb[99] la_oenb[9] user_clock2 user_irq[0] user_irq[1] user_irq[2] wb_clk_i wb_rst_i wbs_ack_o wbs_adr_i[0] wbs_adr_i[10] wbs_adr_i[11] wbs_adr_i[12] wbs_adr_i[13] wbs_adr_i[14] wbs_adr_i[15] wbs_adr_i[16] wbs_adr_i[17] wbs_adr_i[18] wbs_adr_i[19] wbs_adr_i[1] wbs_adr_i[20] wbs_adr_i[21] wbs_adr_i[22] wbs_adr_i[23] wbs_adr_i[24] wbs_adr_i[25] wbs_adr_i[26] wbs_adr_i[27] wbs_adr_i[28] wbs_adr_i[29] wbs_adr_i[2] wbs_adr_i[30] wbs_adr_i[31] wbs_adr_i[3] wbs_adr_i[4] wbs_adr_i[5] wbs_adr_i[6] wbs_adr_i[7] wbs_adr_i[8] wbs_adr_i[9] wbs_cyc_i wbs_dat_i[0] wbs_dat_i[10] wbs_dat_i[11] wbs_dat_i[12] wbs_dat_i[13] wbs_dat_i[14] wbs_dat_i[15] wbs_dat_i[16] wbs_dat_i[17] wbs_dat_i[18] wbs_dat_i[19] wbs_dat_i[1] wbs_dat_i[20] wbs_dat_i[21] wbs_dat_i[22] wbs_dat_i[23] wbs_dat_i[24] wbs_dat_i[25] wbs_dat_i[26] wbs_dat_i[27] wbs_dat_i[28] wbs_dat_i[29] wbs_dat_i[2] wbs_dat_i[30] wbs_dat_i[31] wbs_dat_i[3] wbs_dat_i[4] wbs_dat_i[5] wbs_dat_i[6] wbs_dat_i[7] wbs_dat_i[8] wbs_dat_i[9] wbs_dat_o[0] wbs_dat_o[10] wbs_dat_o[11] wbs_dat_o[12] wbs_dat_o[13] wbs_dat_o[14] wbs_dat_o[15] wbs_dat_o[16] wbs_dat_o[17] wbs_dat_o[18] wbs_dat_o[19] wbs_dat_o[1] wbs_dat_o[20] wbs_dat_o[21] wbs_dat_o[22] wbs_dat_o[23] wbs_dat_o[24] wbs_dat_o[25] wbs_dat_o[26] wbs_dat_o[27] wbs_dat_o[28] wbs_dat_o[29] wbs_dat_o[2] wbs_dat_o[30] wbs_dat_o[31] wbs_dat_o[3] wbs_dat_o[4] wbs_dat_o[5] wbs_dat_o[6] wbs_dat_o[7] wbs_dat_o[8] wbs_dat_o[9] wbs_sel_i[0] wbs_sel_i[1] wbs_sel_i[2] wbs_sel_i[3] wbs_stb_i wbs_we_i io_oeb[0] io_oeb[1] io_oeb[2] io_oeb[30] io_oeb[31] io_oeb[32] io_oeb[33] io_oeb[34] io_oeb[35] io_oeb[36] io_oeb[37] io_oeb[3] io_oeb[4] io_oeb[5] io_oeb[6] io_oeb[10] io_oeb[11] io_oeb[12] io_oeb[13] io_oeb[14] io_oeb[15] io_oeb[16] io_oeb[17] io_oeb[18] io_oeb[19] io_oeb[20] io_oeb[21] io_oeb[22] io_oeb[23] io_oeb[24] io_oeb[25] io_oeb[26] io_oeb[27] io_oeb[28] io_oeb[29] io_oeb[8] io_oeb[9] io_out[10] io_out[11] io_out[12] io_out[13] io_out[14] io_out[15] io_out[16] io_out[17] io_out[18] io_out[19] io_out[20] io_out[21] io_out[22] io_out[23] io_out[24] io_out[25] io_out[26] io_out[27] io_out[28] io_out[29] io_out[8] la_data_out[0] la_data_out[1] la_data_out[2] la_data_out[8] la_data_out[9] la_data_out[10] la_data_out[11] la_data_out[12] la_data_out[13] la_data_out[14] la_data_out[15] la_data_out[3] la_data_out[4] la_data_out[5] la_data_out[6] la_data_out[7]
XANTENNA_257 wbs_stb_i wire9/VGND VSUBS _356_/VPB wire9/VPWR sky130_fd_sc_hd__diode_2
XANTENNA_235 wbs_sel_i[1] wire9/VGND VSUBS _341_/VPB wire9/VPWR sky130_fd_sc_hd__diode_2
XANTENNA_246 wbs_sel_i[1] wire9/VGND VSUBS _342_/VPB wire9/VPWR sky130_fd_sc_hd__diode_2
X_294_ la_oenb[60] _318_/B la_data_in[60] wire9/VGND VSUBS _310_/VPB wire9/VPWR _294_/Y
+ sky130_fd_sc_hd__nor3b_1
X_432_ wire9/VGND VSUBS _434_/VPB wire9/VPWR _432_/HI la_data_out[101] sky130_fd_sc_hd__conb_1
X_363_ wire9/VGND VSUBS _364_/VPB wire9/VPWR _363_/HI la_data_out[32] sky130_fd_sc_hd__conb_1
XANTENNA_213 wbs_sel_i[0] wire9/VGND VSUBS _247_/VPB wire9/VPWR sky130_fd_sc_hd__diode_2
XANTENNA_224 wbs_sel_i[0] wire9/VGND VSUBS _247_/VPB wire9/VPWR sky130_fd_sc_hd__diode_2
XANTENNA_268 wbs_we_i wire9/VGND VSUBS _242_/VPB wire9/VPWR sky130_fd_sc_hd__diode_2
XANTENNA_202 wbs_dat_i[9] wire9/VGND VSUBS wire2/VPB wire9/VPWR sky130_fd_sc_hd__diode_2
XANTENNA_279 wbs_ack_o wire9/VGND VSUBS _283_/VPB wire9/VPWR sky130_fd_sc_hd__diode_2
X_415_ wire9/VGND VSUBS _417_/VPB wire9/VPWR _415_/HI la_data_out[84] sky130_fd_sc_hd__conb_1
X_346_ _360_/CLK _346_/D wire9/VGND VSUBS _346_/VPB wire9/VPWR io_out[2] sky130_fd_sc_hd__dfxtp_1
X_277_ la_oenb[58] _318_/B la_data_in[58] wire9/VGND VSUBS _393_/VPB wire9/VPWR _277_/Y
+ sky130_fd_sc_hd__nor3b_1
X_200_ _200_/A _200_/B wire9/VGND VSUBS _200_/VPB wire9/VPWR _201_/B sky130_fd_sc_hd__nor2_1
X_329_ _351_/CLK io_out[1] _167_/Y wire9/VGND VSUBS _329_/VPB wire9/VPWR _329_/Q sky130_fd_sc_hd__edfxtp_1
XANTENNA_5 la_data_in[59] wire9/VGND VSUBS _381_/VPB wire9/VPWR sky130_fd_sc_hd__diode_2
XANTENNA_258 wbs_stb_i wire9/VGND VSUBS _356_/VPB wire9/VPWR sky130_fd_sc_hd__diode_2
XANTENNA_236 wbs_sel_i[1] wire9/VGND VSUBS _341_/VPB wire9/VPWR sky130_fd_sc_hd__diode_2
X_293_ _289_/Y _292_/Y io_oeb[7] wire9/VGND VSUBS _293_/VPB wire9/VPWR _355_/D sky130_fd_sc_hd__a21oi_1
XANTENNA_247 wbs_sel_i[1] wire9/VGND VSUBS _342_/VPB wire9/VPWR sky130_fd_sc_hd__diode_2
X_362_ wire9/VGND VSUBS _491_/VPB wire9/VPWR _362_/HI la_data_out[31] sky130_fd_sc_hd__conb_1
X_431_ wire9/VGND VSUBS _434_/VPB wire9/VPWR _431_/HI la_data_out[100] sky130_fd_sc_hd__conb_1
XANTENNA_225 wbs_sel_i[0] wire9/VGND VSUBS _247_/VPB wire9/VPWR sky130_fd_sc_hd__diode_2
XANTENNA_214 wbs_sel_i[0] wire9/VGND VSUBS _247_/VPB wire9/VPWR sky130_fd_sc_hd__diode_2
XANTENNA_269 wbs_we_i wire9/VGND VSUBS _242_/VPB wire9/VPWR sky130_fd_sc_hd__diode_2
XANTENNA_203 wbs_dat_i[9] wire9/VGND VSUBS wire2/VPB wire9/VPWR sky130_fd_sc_hd__diode_2
X_414_ wire9/VGND VSUBS _417_/VPB wire9/VPWR _414_/HI la_data_out[83] sky130_fd_sc_hd__conb_1
X_345_ _360_/CLK _345_/D wire9/VGND VSUBS _345_/VPB wire9/VPWR io_out[1] sky130_fd_sc_hd__dfxtp_1
X_276_ _272_/Y _275_/Y io_oeb[7] wire9/VGND VSUBS _283_/VPB wire9/VPWR _353_/D sky130_fd_sc_hd__a21oi_1
X_328_ _356_/CLK io_out[0] _167_/Y wire9/VGND VSUBS _328_/VPB wire9/VPWR wbs_dat_o[0]
+ sky130_fd_sc_hd__edfxtp_1
X_259_ io_out[30] _252_/B _323_/B wire9/VGND VSUBS _259_/VPB wire9/VPWR _259_/Y sky130_fd_sc_hd__o21bai_1
XANTENNA_6 la_data_in[60] wire9/VGND VSUBS _184_/VPB wire9/VPWR sky130_fd_sc_hd__diode_2
X_430_ wire9/VGND VSUBS _430_/VPB wire9/VPWR _430_/HI la_data_out[99] sky130_fd_sc_hd__conb_1
XANTENNA_259 wbs_stb_i wire9/VGND VSUBS _181_/VPB wire9/VPWR sky130_fd_sc_hd__diode_2
XANTENNA_237 wbs_sel_i[1] wire9/VGND VSUBS _341_/VPB wire9/VPWR sky130_fd_sc_hd__diode_2
XANTENNA_248 wbs_sel_i[1] wire9/VGND VSUBS _342_/VPB wire9/VPWR sky130_fd_sc_hd__diode_2
X_292_ wbs_dat_i[11] _324_/A _288_/Y _291_/Y _165_/X wire9/VGND VSUBS _292_/VPB wire9/VPWR
+ _292_/Y sky130_fd_sc_hd__o221ai_1
X_361_ wire9/VGND VSUBS _491_/VPB wire9/VPWR _361_/HI la_data_out[30] sky130_fd_sc_hd__conb_1
XANTENNA_226 wbs_sel_i[0] wire9/VGND VSUBS _247_/VPB wire9/VPWR sky130_fd_sc_hd__diode_2
XANTENNA_215 wbs_sel_i[0] wire9/VGND VSUBS _247_/VPB wire9/VPWR sky130_fd_sc_hd__diode_2
XANTENNA_204 wbs_dat_i[9] wire9/VGND VSUBS wire2/VPB wire9/VPWR sky130_fd_sc_hd__diode_2
X_413_ wire9/VGND VSUBS _417_/VPB wire9/VPWR _413_/HI la_data_out[82] sky130_fd_sc_hd__conb_1
X_275_ wbs_dat_i[9] _324_/A _271_/Y _274_/Y _165_/X wire9/VGND VSUBS wire2/VPB wire9/VPWR
+ _275_/Y sky130_fd_sc_hd__o221ai_1
X_344_ _358_/CLK _344_/D wire9/VGND VSUBS _344_/VPB wire9/VPWR io_out[0] sky130_fd_sc_hd__dfxtp_1
X_258_ la_oenb[56] _318_/B la_data_in[56] wire9/VGND VSUBS _258_/VPB wire9/VPWR _258_/Y
+ sky130_fd_sc_hd__nor3b_1
X_189_ wbs_dat_i[0] _255_/A _165_/X wire9/VGND VSUBS _243_/VPB wire9/VPWR _190_/B
+ sky130_fd_sc_hd__o21ai_0
X_327_ io_oeb[7] _327_/B wire9/VGND VSUBS wire2/VPB wire9/VPWR _360_/D sky130_fd_sc_hd__nor2_1
XANTENNA_7 la_data_in[62] wire9/VGND VSUBS _181_/VPB wire9/VPWR sky130_fd_sc_hd__diode_2
XANTENNA_238 wbs_sel_i[1] wire9/VGND VSUBS _341_/VPB wire9/VPWR sky130_fd_sc_hd__diode_2
X_291_ _324_/A _291_/B wire9/VGND VSUBS _293_/VPB wire9/VPWR _291_/Y sky130_fd_sc_hd__nand2_1
XANTENNA_249 wbs_sel_i[1] wire9/VGND VSUBS _342_/VPB wire9/VPWR sky130_fd_sc_hd__diode_2
XANTENNA_216 wbs_sel_i[0] wire9/VGND VSUBS _247_/VPB wire9/VPWR sky130_fd_sc_hd__diode_2
XANTENNA_227 wbs_sel_i[0] wire9/VGND VSUBS _247_/VPB wire9/VPWR sky130_fd_sc_hd__diode_2
XANTENNA_205 wbs_dat_i[9] wire9/VGND VSUBS wire2/VPB wire9/VPWR sky130_fd_sc_hd__diode_2
X_360_ _360_/CLK _360_/D wire9/VGND VSUBS wire2/VPB wire9/VPWR wire2/A sky130_fd_sc_hd__dfxtp_2
X_489_ wire9/VGND VSUBS _489_/VPB wire9/VPWR _489_/HI la_data_out[27] sky130_fd_sc_hd__conb_1
Xspare_inverter_0 spare_inverter_0/A wire9/VGND VSUBS spare_tielo_drv/VPB wire9/VPWR
+ spare_inverter_0/Y sky130_fd_sc_hd__inv_1
X_412_ wire9/VGND VSUBS _412_/VPB wire9/VPWR _412_/HI la_data_out[81] sky130_fd_sc_hd__conb_1
X_343_ _351_/CLK io_out[37] _167_/Y wire9/VGND VSUBS _343_/VPB wire9/VPWR wire3/A
+ sky130_fd_sc_hd__edfxtp_1
X_274_ _324_/A _274_/B wire9/VGND VSUBS _283_/VPB wire9/VPWR _274_/Y sky130_fd_sc_hd__nand2_1
X_257_ _253_/Y _256_/Y io_oeb[7] wire9/VGND VSUBS _351_/VPB wire9/VPWR _351_/D sky130_fd_sc_hd__a21oi_1
X_188_ io_out[0] _323_/B _187_/Y wire9/VGND VSUBS _188_/VPB wire9/VPWR _190_/A sky130_fd_sc_hd__a21oi_1
X_326_ _322_/Y _325_/Y io_oeb[7] wire9/VGND VSUBS _359_/VPB wire9/VPWR _359_/D sky130_fd_sc_hd__a21oi_1
X_309_ io_oeb[7] _309_/B wire9/VGND VSUBS _341_/VPB wire9/VPWR _357_/D sky130_fd_sc_hd__nor2_1
XANTENNA_8 la_data_in[63] wire9/VGND VSUBS _318_/VPB wire9/VPWR sky130_fd_sc_hd__diode_2
XANTENNA_239 wbs_sel_i[1] wire9/VGND VSUBS _341_/VPB wire9/VPWR sky130_fd_sc_hd__diode_2
XANTENNA_217 wbs_sel_i[0] wire9/VGND VSUBS _247_/VPB wire9/VPWR sky130_fd_sc_hd__diode_2
XANTENNA_228 wbs_sel_i[0] wire9/VGND VSUBS _242_/VPB wire9/VPWR sky130_fd_sc_hd__diode_2
XANTENNA_206 wbs_dat_i[9] wire9/VGND VSUBS wire2/VPB wire9/VPWR sky130_fd_sc_hd__diode_2
X_290_ io_out[33] _323_/B wire9/VGND VSUBS _293_/VPB wire9/VPWR _291_/B sky130_fd_sc_hd__nand2_1
X_488_ wire9/VGND VSUBS _489_/VPB wire9/VPWR _488_/HI la_data_out[26] sky130_fd_sc_hd__conb_1
Xspare_inverter_1 spare_inverter_1/A wire9/VGND VSUBS spare_inverter_1/VPB wire9/VPWR
+ spare_inverter_1/Y sky130_fd_sc_hd__inv_1
X_411_ wire9/VGND VSUBS _412_/VPB wire9/VPWR _411_/HI la_data_out[80] sky130_fd_sc_hd__conb_1
X_342_ _351_/CLK io_out[36] _167_/Y wire9/VGND VSUBS _342_/VPB wire9/VPWR wire4/A
+ sky130_fd_sc_hd__edfxtp_1
X_273_ io_out[31] _323_/B wire9/VGND VSUBS wire2/VPB wire9/VPWR _274_/B sky130_fd_sc_hd__nand2_1
X_187_ io_out[0] _323_/B _255_/A wire9/VGND VSUBS _243_/VPB wire9/VPWR _187_/Y sky130_fd_sc_hd__o21ai_0
X_325_ wbs_dat_i[15] _324_/A _321_/Y _324_/Y _165_/X wire9/VGND VSUBS _359_/VPB wire9/VPWR
+ _325_/Y sky130_fd_sc_hd__o221ai_1
X_256_ wbs_dat_i[7] _255_/A _252_/Y _255_/Y _165_/X wire9/VGND VSUBS _256_/VPB wire9/VPWR
+ _256_/Y sky130_fd_sc_hd__o221ai_1
Xclkbuf_2_1__f_mprj.counter.clk clkbuf_0_mprj.counter.clk/X wire9/VGND VSUBS _359_/VPB
+ wire9/VPWR _360_/CLK sky130_fd_sc_hd__clkbuf_16
Xclkload0 _360_/CLK wire9/VGND VSUBS _359_/VPB wire9/VPWR clkload0/Y sky130_fd_sc_hd__bufinv_16
X_308_ _165_/X _305_/Y _306_/Y _307_/Y wire9/VGND VSUBS _341_/VPB wire9/VPWR _309_/B
+ sky130_fd_sc_hd__o22a_1
X_239_ _239_/A _239_/B wire9/VGND VSUBS _239_/VPB wire9/VPWR _240_/B sky130_fd_sc_hd__nor2_1
XANTENNA_9 la_data_in[64] wire9/VGND VSUBS ANTENNA_9/VPB wire9/VPWR sky130_fd_sc_hd__diode_2
XANTENNA_229 wbs_sel_i[0] wire9/VGND VSUBS _247_/VPB wire9/VPWR sky130_fd_sc_hd__diode_2
XANTENNA_218 wbs_sel_i[0] wire9/VGND VSUBS _247_/VPB wire9/VPWR sky130_fd_sc_hd__diode_2
XANTENNA_207 wbs_dat_i[9] wire9/VGND VSUBS wire2/VPB wire9/VPWR sky130_fd_sc_hd__diode_2
X_487_ wire9/VGND VSUBS _489_/VPB wire9/VPWR _487_/HI la_data_out[25] sky130_fd_sc_hd__conb_1
X_410_ wire9/VGND VSUBS _412_/VPB wire9/VPWR _410_/HI la_data_out[79] sky130_fd_sc_hd__conb_1
X_341_ _358_/CLK io_out[35] _167_/Y wire9/VGND VSUBS _341_/VPB wire9/VPWR wire5/A
+ sky130_fd_sc_hd__edfxtp_1
X_272_ _268_/Y _271_/Y _327_/B wire9/VGND VSUBS _359_/VPB wire9/VPWR _272_/Y sky130_fd_sc_hd__o21ai_0
X_186_ wbs_we_i wbs_sel_i[0] wire9/VGND VSUBS _247_/VPB wire9/VPWR _255_/A sky130_fd_sc_hd__nand2_1
X_324_ _324_/A _324_/B wire9/VGND VSUBS _359_/VPB wire9/VPWR _324_/Y sky130_fd_sc_hd__nand2_1
X_255_ _255_/A _255_/B wire9/VGND VSUBS _359_/VPB wire9/VPWR _255_/Y sky130_fd_sc_hd__nand2_1
Xclkload1 _358_/CLK wire9/VGND VSUBS _356_/VPB wire9/VPWR clkload1/Y sky130_fd_sc_hd__bufinv_16
X_307_ wbs_dat_i[13] _324_/A _165_/X wire9/VGND VSUBS _342_/VPB wire9/VPWR _307_/Y
+ sky130_fd_sc_hd__o21ai_0
X_238_ _255_/A _234_/Y _236_/Y _237_/Y wire9/VGND VSUBS _238_/VPB wire9/VPWR _239_/B
+ sky130_fd_sc_hd__a31oi_1
X_169_ la_oenb[48] _318_/B wire9/VGND VSUBS _318_/VPB wire9/VPWR _170_/B sky130_fd_sc_hd__nor2_1
XANTENNA_219 wbs_sel_i[0] wire9/VGND VSUBS _247_/VPB wire9/VPWR sky130_fd_sc_hd__diode_2
XANTENNA_208 wbs_dat_i[9] wire9/VGND VSUBS wire2/VPB wire9/VPWR sky130_fd_sc_hd__diode_2
X_486_ wire9/VGND VSUBS _489_/VPB wire9/VPWR _486_/HI la_data_out[24] sky130_fd_sc_hd__conb_1
X_340_ _356_/CLK io_out[34] _167_/Y wire9/VGND VSUBS _340_/VPB wire9/VPWR wbs_dat_o[12]
+ sky130_fd_sc_hd__edfxtp_1
X_271_ _323_/B _295_/D _271_/C wire9/VGND VSUBS _271_/VPB wire9/VPWR _271_/Y sky130_fd_sc_hd__nor3_1
X_469_ wire9/VGND VSUBS _469_/VPB wire9/VPWR _469_/HI wbs_dat_o[23] sky130_fd_sc_hd__conb_1
X_254_ io_out[7] _323_/B wire9/VGND VSUBS _351_/VPB wire9/VPWR _255_/B sky130_fd_sc_hd__nand2_1
X_185_ io_out[0] _323_/B _170_/Y wire9/VGND VSUBS _185_/VPB wire9/VPWR _185_/Y sky130_fd_sc_hd__o21ai_0
X_323_ io_out[37] _323_/B wire9/VGND VSUBS _335_/VPB wire9/VPWR _324_/B sky130_fd_sc_hd__nand2_1
Xclkload2 _356_/CLK wire9/VGND VSUBS clkload2/VPB wire9/VPWR clkload2/Y sky130_fd_sc_hd__inv_6
X_168_ la_data_in[64] wb_clk_i la_oenb[64] wire9/VGND VSUBS _320_/VPB wire9/VPWR _168_/X
+ sky130_fd_sc_hd__mux2_1
X_306_ io_out[35] _323_/B _262_/X _304_/Y wire9/VGND VSUBS _341_/VPB wire9/VPWR _306_/Y
+ sky130_fd_sc_hd__a211oi_1
X_237_ wbs_dat_i[5] _255_/A _165_/X wire9/VGND VSUBS _335_/VPB wire9/VPWR _237_/Y
+ sky130_fd_sc_hd__o21ai_0
XANTENNA_209 wbs_sel_i[0] wire9/VGND VSUBS _247_/VPB wire9/VPWR sky130_fd_sc_hd__diode_2
X_485_ wire9/VGND VSUBS _485_/VPB wire9/VPWR _485_/HI la_data_out[23] sky130_fd_sc_hd__conb_1
X_270_ io_out[30] _252_/B io_out[31] wire9/VGND VSUBS _283_/VPB wire9/VPWR _271_/C
+ sky130_fd_sc_hd__a21oi_1
X_399_ wire9/VGND VSUBS _405_/VPB wire9/VPWR _399_/HI la_data_out[68] sky130_fd_sc_hd__conb_1
X_468_ wire9/VGND VSUBS _474_/VPB wire9/VPWR _468_/HI wbs_dat_o[22] sky130_fd_sc_hd__conb_1
Xload_slew1 wbs_ack_o wire9/VGND VSUBS _283_/VPB wire9/VPWR _166_/A_N sky130_fd_sc_hd__clkbuf_1
X_322_ _318_/Y _321_/Y _327_/B wire9/VGND VSUBS wire2/VPB wire9/VPWR _322_/Y sky130_fd_sc_hd__o21ai_0
X_184_ _184_/A _184_/B _184_/C wire9/VGND VSUBS _184_/VPB wire9/VPWR _323_/B sky130_fd_sc_hd__nand3_1
X_253_ _249_/Y _252_/Y _327_/B wire9/VGND VSUBS _256_/VPB wire9/VPWR _253_/Y sky130_fd_sc_hd__o21ai_0
X_305_ la_data_in[61] _183_/A _304_/Y wire9/VGND VSUBS _305_/VPB wire9/VPWR _305_/Y
+ sky130_fd_sc_hd__a21oi_1
X_236_ io_out[5] _323_/B wire9/VGND VSUBS _349_/VPB wire9/VPWR _236_/Y sky130_fd_sc_hd__nand2_1
X_167_ io_oeb[7] _327_/B wire9/VGND VSUBS _167_/VPB wire9/VPWR _167_/Y sky130_fd_sc_hd__nor2_1
X_219_ _255_/A _215_/Y _217_/Y _218_/Y wire9/VGND VSUBS _220_/VPB wire9/VPWR _220_/B
+ sky130_fd_sc_hd__a31oi_1
X_484_ wire9/VGND VSUBS _485_/VPB wire9/VPWR _484_/HI la_data_out[22] sky130_fd_sc_hd__conb_1
X_398_ wire9/VGND VSUBS _398_/VPB wire9/VPWR _398_/HI la_data_out[67] sky130_fd_sc_hd__conb_1
X_467_ wire9/VGND VSUBS _467_/VPB wire9/VPWR _467_/HI wbs_dat_o[21] sky130_fd_sc_hd__conb_1
X_183_ _183_/A _183_/B _183_/C _183_/D wire9/VGND VSUBS _356_/VPB wire9/VPWR _184_/C
+ sky130_fd_sc_hd__nor4_1
X_321_ _323_/B _321_/B _321_/C wire9/VGND VSUBS _358_/VPB wire9/VPWR _321_/Y sky130_fd_sc_hd__nor3_1
X_252_ _323_/B _252_/B _252_/C wire9/VGND VSUBS _259_/VPB wire9/VPWR _252_/Y sky130_fd_sc_hd__nor3_1
X_304_ io_out[34] io_out[35] _296_/B _303_/Y _323_/B wire9/VGND VSUBS _320_/VPB wire9/VPWR
+ _304_/Y sky130_fd_sc_hd__a311oi_1
X_235_ _232_/Y _234_/Y _165_/X wire9/VGND VSUBS _235_/VPB wire9/VPWR _239_/A sky130_fd_sc_hd__a21oi_1
XANTENNA_190 wbs_dat_i[8] wire9/VGND VSUBS _352_/VPB wire9/VPWR sky130_fd_sc_hd__diode_2
X_166_ _166_/A_N _318_/B wire9/VGND VSUBS _167_/VPB wire9/VPWR _327_/B sky130_fd_sc_hd__nand2b_1
X_218_ wbs_dat_i[3] _255_/A _165_/X wire9/VGND VSUBS _247_/VPB wire9/VPWR _218_/Y
+ sky130_fd_sc_hd__o21ai_0
XANTENNA_90 wbs_dat_i[13] wire9/VGND VSUBS _342_/VPB wire9/VPWR sky130_fd_sc_hd__diode_2
X_483_ wire9/VGND VSUBS _485_/VPB wire9/VPWR _483_/HI la_data_out[21] sky130_fd_sc_hd__conb_1
X_397_ wire9/VGND VSUBS _398_/VPB wire9/VPWR _397_/HI la_data_out[66] sky130_fd_sc_hd__conb_1
X_466_ wire9/VGND VSUBS _466_/VPB wire9/VPWR _466_/HI wbs_dat_o[20] sky130_fd_sc_hd__conb_1
X_182_ la_oenb[48] la_oenb[58] wbs_stb_i wbs_cyc_i wire9/VGND VSUBS _356_/VPB wire9/VPWR
+ _183_/D sky130_fd_sc_hd__a22oi_1
X_320_ io_out[35] io_out[36] _319_/D io_out[37] wire9/VGND VSUBS _320_/VPB wire9/VPWR
+ _321_/C sky130_fd_sc_hd__a31oi_1
X_251_ io_out[7] _269_/D wire9/VGND VSUBS _283_/VPB wire9/VPWR _252_/C sky130_fd_sc_hd__nor2_1
X_449_ wire9/VGND VSUBS _450_/VPB wire9/VPWR _449_/HI la_data_out[118] sky130_fd_sc_hd__conb_1
X_303_ io_out[32] io_out[33] io_out[34] _295_/D io_out[35] wire9/VGND VSUBS _303_/VPB
+ wire9/VPWR _303_/Y sky130_fd_sc_hd__a41oi_1
XANTENNA_191 wbs_dat_i[8] wire9/VGND VSUBS _352_/VPB wire9/VPWR sky130_fd_sc_hd__diode_2
XANTENNA_180 wbs_dat_i[6] wire9/VGND VSUBS _247_/VPB wire9/VPWR sky130_fd_sc_hd__diode_2
X_234_ io_out[5] _224_/B _233_/Y wire9/VGND VSUBS _242_/VPB wire9/VPWR _234_/Y sky130_fd_sc_hd__o21ai_0
X_165_ _318_/B _166_/A_N wire9/VGND VSUBS _167_/VPB wire9/VPWR _165_/X sky130_fd_sc_hd__lpflow_isobufsrc_1
X_217_ io_out[3] _323_/B wire9/VGND VSUBS _247_/VPB wire9/VPWR _217_/Y sky130_fd_sc_hd__nand2_1
XANTENNA_80 wbs_dat_i[12] wire9/VGND VSUBS _342_/VPB wire9/VPWR sky130_fd_sc_hd__diode_2
XANTENNA_91 wbs_dat_i[13] wire9/VGND VSUBS _342_/VPB wire9/VPWR sky130_fd_sc_hd__diode_2
X_482_ wire9/VGND VSUBS _485_/VPB wire9/VPWR _482_/HI la_data_out[20] sky130_fd_sc_hd__conb_1
X_396_ wire9/VGND VSUBS _398_/VPB wire9/VPWR _396_/HI la_data_out[65] sky130_fd_sc_hd__conb_1
X_465_ wire9/VGND VSUBS _469_/VPB wire9/VPWR _465_/HI wbs_dat_o[19] sky130_fd_sc_hd__conb_1
X_181_ la_oenb[56] la_oenb[60] wbs_stb_i wbs_cyc_i wire9/VGND VSUBS _181_/VPB wire9/VPWR
+ _183_/C sky130_fd_sc_hd__a22oi_1
X_250_ io_out[7] _269_/D wire9/VGND VSUBS _259_/VPB wire9/VPWR _252_/B sky130_fd_sc_hd__and2_0
X_448_ wire9/VGND VSUBS _450_/VPB wire9/VPWR _448_/HI la_data_out[117] sky130_fd_sc_hd__conb_1
X_379_ wire9/VGND VSUBS _381_/VPB wire9/VPWR _379_/HI la_data_out[48] sky130_fd_sc_hd__conb_1
X_302_ _298_/Y _301_/Y io_oeb[7] wire9/VGND VSUBS _358_/VPB wire9/VPWR _356_/D sky130_fd_sc_hd__a21oi_1
X_164_ wbs_stb_i wbs_cyc_i wire9/VGND VSUBS _393_/VPB wire9/VPWR _318_/B sky130_fd_sc_hd__and2_0
X_233_ io_out[5] _224_/B _323_/B wire9/VGND VSUBS _235_/VPB wire9/VPWR _233_/Y sky130_fd_sc_hd__a21oi_1
XANTENNA_192 wbs_dat_i[8] wire9/VGND VSUBS _352_/VPB wire9/VPWR sky130_fd_sc_hd__diode_2
XANTENNA_181 wbs_dat_i[6] wire9/VGND VSUBS _247_/VPB wire9/VPWR sky130_fd_sc_hd__diode_2
XANTENNA_170 wbs_dat_i[5] wire9/VGND VSUBS _359_/VPB wire9/VPWR sky130_fd_sc_hd__diode_2
Xspare_dff_0 spare_dff_0/CLK spare_dff_0/D spare_dff_0/RESET_B wire9/VGND VSUBS spare_dff_0/VPB
+ wire9/VPWR spare_dff_0/Q sky130_fd_sc_hd__dfrtp_1
X_216_ _212_/Y _215_/Y _165_/X wire9/VGND VSUBS _216_/VPB wire9/VPWR _220_/A sky130_fd_sc_hd__a21oi_1
XANTENNA_81 wbs_dat_i[12] wire9/VGND VSUBS _342_/VPB wire9/VPWR sky130_fd_sc_hd__diode_2
XANTENNA_92 wbs_dat_i[13] wire9/VGND VSUBS _342_/VPB wire9/VPWR sky130_fd_sc_hd__diode_2
XANTENNA_70 wbs_dat_i[11] wire9/VGND VSUBS _292_/VPB wire9/VPWR sky130_fd_sc_hd__diode_2
Xclkbuf_2_2__f_mprj.counter.clk clkbuf_0_mprj.counter.clk/X wire9/VGND VSUBS _320_/VPB
+ wire9/VPWR _358_/CLK sky130_fd_sc_hd__clkbuf_16
X_481_ wire9/VGND VSUBS _481_/VPB wire9/VPWR _481_/HI la_data_out[19] sky130_fd_sc_hd__conb_1
X_464_ wire9/VGND VSUBS _467_/VPB wire9/VPWR _464_/HI wbs_dat_o[18] sky130_fd_sc_hd__conb_1
X_395_ wire9/VGND VSUBS _398_/VPB wire9/VPWR _395_/HI la_data_out[64] sky130_fd_sc_hd__conb_1
X_180_ la_oenb[53] la_oenb[62] la_oenb[63] wbs_stb_i wbs_cyc_i wire9/VGND VSUBS _356_/VPB
+ wire9/VPWR _183_/B sky130_fd_sc_hd__a32oi_1
X_447_ wire9/VGND VSUBS _450_/VPB wire9/VPWR _447_/HI la_data_out[116] sky130_fd_sc_hd__conb_1
X_378_ wire9/VGND VSUBS _381_/VPB wire9/VPWR _378_/HI la_data_out[47] sky130_fd_sc_hd__conb_1
X_301_ wbs_dat_i[12] _324_/A _297_/Y _300_/Y _165_/X wire9/VGND VSUBS _342_/VPB wire9/VPWR
+ _301_/Y sky130_fd_sc_hd__o221ai_1
X_163_ la_data_in[65] wb_rst_i la_oenb[65] wire9/VGND VSUBS _485_/VPB wire9/VPWR io_oeb[7]
+ sky130_fd_sc_hd__mux2_1
X_232_ la_data_in[53] _232_/B wire9/VGND VSUBS _345_/VPB wire9/VPWR _232_/Y sky130_fd_sc_hd__nand2_1
XANTENNA_193 wbs_dat_i[8] wire9/VGND VSUBS _352_/VPB wire9/VPWR sky130_fd_sc_hd__diode_2
XANTENNA_160 wbs_dat_i[4] wire9/VGND VSUBS _350_/VPB wire9/VPWR sky130_fd_sc_hd__diode_2
XANTENNA_182 wbs_dat_i[6] wire9/VGND VSUBS _247_/VPB wire9/VPWR sky130_fd_sc_hd__diode_2
XANTENNA_171 wbs_dat_i[5] wire9/VGND VSUBS wire2/VPB wire9/VPWR sky130_fd_sc_hd__diode_2
X_215_ io_out[3] _205_/C _214_/Y wire9/VGND VSUBS _247_/VPB wire9/VPWR _215_/Y sky130_fd_sc_hd__o21ai_0
XANTENNA_82 wbs_dat_i[12] wire9/VGND VSUBS _342_/VPB wire9/VPWR sky130_fd_sc_hd__diode_2
XANTENNA_93 wbs_dat_i[13] wire9/VGND VSUBS _342_/VPB wire9/VPWR sky130_fd_sc_hd__diode_2
XANTENNA_71 wbs_dat_i[11] wire9/VGND VSUBS _292_/VPB wire9/VPWR sky130_fd_sc_hd__diode_2
XANTENNA_60 wbs_dat_i[10] wire9/VGND VSUBS _283_/VPB wire9/VPWR sky130_fd_sc_hd__diode_2
X_480_ wire9/VGND VSUBS _481_/VPB wire9/VPWR _480_/HI la_data_out[18] sky130_fd_sc_hd__conb_1
X_394_ wire9/VGND VSUBS _398_/VPB wire9/VPWR _394_/HI la_data_out[63] sky130_fd_sc_hd__conb_1
X_463_ wire9/VGND VSUBS _469_/VPB wire9/VPWR _463_/HI wbs_dat_o[17] sky130_fd_sc_hd__conb_1
X_446_ wire9/VGND VSUBS _446_/VPB wire9/VPWR _446_/HI la_data_out[115] sky130_fd_sc_hd__conb_1
X_377_ wire9/VGND VSUBS _377_/VPB wire9/VPWR _377_/HI la_data_out[46] sky130_fd_sc_hd__conb_1
X_300_ _324_/A _300_/B wire9/VGND VSUBS _300_/VPB wire9/VPWR _300_/Y sky130_fd_sc_hd__nand2_1
X_231_ io_oeb[7] _231_/B wire9/VGND VSUBS _332_/VPB wire9/VPWR _348_/D sky130_fd_sc_hd__nor2_1
X_429_ wire9/VGND VSUBS _429_/VPB wire9/VPWR _429_/HI la_data_out[98] sky130_fd_sc_hd__conb_1
XANTENNA_194 wbs_dat_i[8] wire9/VGND VSUBS _352_/VPB wire9/VPWR sky130_fd_sc_hd__diode_2
XANTENNA_161 wbs_dat_i[4] wire9/VGND VSUBS _350_/VPB wire9/VPWR sky130_fd_sc_hd__diode_2
XANTENNA_183 wbs_dat_i[6] wire9/VGND VSUBS _247_/VPB wire9/VPWR sky130_fd_sc_hd__diode_2
XANTENNA_150 wbs_dat_i[3] wire9/VGND VSUBS _247_/VPB wire9/VPWR sky130_fd_sc_hd__diode_2
XANTENNA_172 wbs_dat_i[5] wire9/VGND VSUBS _283_/VPB wire9/VPWR sky130_fd_sc_hd__diode_2
X_214_ _323_/B _242_/D wire9/VGND VSUBS _247_/VPB wire9/VPWR _214_/Y sky130_fd_sc_hd__nor2_1
XANTENNA_83 wbs_dat_i[12] wire9/VGND VSUBS _293_/VPB wire9/VPWR sky130_fd_sc_hd__diode_2
XANTENNA_94 wbs_dat_i[13] wire9/VGND VSUBS _342_/VPB wire9/VPWR sky130_fd_sc_hd__diode_2
XANTENNA_72 wbs_dat_i[11] wire9/VGND VSUBS _292_/VPB wire9/VPWR sky130_fd_sc_hd__diode_2
XANTENNA_61 wbs_dat_i[10] wire9/VGND VSUBS _283_/VPB wire9/VPWR sky130_fd_sc_hd__diode_2
XANTENNA_50 wbs_dat_i[0] wire9/VGND VSUBS _243_/VPB wire9/VPWR sky130_fd_sc_hd__diode_2
X_393_ wire9/VGND VSUBS _393_/VPB wire9/VPWR _393_/HI la_data_out[62] sky130_fd_sc_hd__conb_1
X_462_ wire9/VGND VSUBS _474_/VPB wire9/VPWR _462_/HI wbs_dat_o[16] sky130_fd_sc_hd__conb_1
X_445_ wire9/VGND VSUBS _446_/VPB wire9/VPWR _445_/HI la_data_out[114] sky130_fd_sc_hd__conb_1
X_376_ wire9/VGND VSUBS _377_/VPB wire9/VPWR _376_/HI la_data_out[45] sky130_fd_sc_hd__conb_1
X_230_ _230_/A _230_/B wire9/VGND VSUBS _348_/VPB wire9/VPWR _231_/B sky130_fd_sc_hd__nor2_1
X_428_ wire9/VGND VSUBS _429_/VPB wire9/VPWR _428_/HI la_data_out[97] sky130_fd_sc_hd__conb_1
XANTENNA_195 wbs_dat_i[8] wire9/VGND VSUBS _352_/VPB wire9/VPWR sky130_fd_sc_hd__diode_2
XANTENNA_162 wbs_dat_i[4] wire9/VGND VSUBS _348_/VPB wire9/VPWR sky130_fd_sc_hd__diode_2
XANTENNA_184 wbs_dat_i[6] wire9/VGND VSUBS _247_/VPB wire9/VPWR sky130_fd_sc_hd__diode_2
XANTENNA_151 wbs_dat_i[3] wire9/VGND VSUBS _247_/VPB wire9/VPWR sky130_fd_sc_hd__diode_2
XANTENNA_140 wbs_dat_i[2] wire9/VGND VSUBS _247_/VPB wire9/VPWR sky130_fd_sc_hd__diode_2
XANTENNA_173 wbs_dat_i[5] wire9/VGND VSUBS wire2/VPB wire9/VPWR sky130_fd_sc_hd__diode_2
X_359_ _360_/CLK _359_/D wire9/VGND VSUBS _359_/VPB wire9/VPWR io_out[37] sky130_fd_sc_hd__dfxtp_1
X_213_ io_out[3] io_out[2] io_out[0] io_out[1] wire9/VGND VSUBS _213_/VPB wire9/VPWR
+ _242_/D sky130_fd_sc_hd__and4_1
XANTENNA_40 wbs_cyc_i wire9/VGND VSUBS _181_/VPB wire9/VPWR sky130_fd_sc_hd__diode_2
XANTENNA_84 wbs_dat_i[12] wire9/VGND VSUBS _293_/VPB wire9/VPWR sky130_fd_sc_hd__diode_2
XANTENNA_95 wbs_dat_i[13] wire9/VGND VSUBS _342_/VPB wire9/VPWR sky130_fd_sc_hd__diode_2
XANTENNA_73 wbs_dat_i[11] wire9/VGND VSUBS _292_/VPB wire9/VPWR sky130_fd_sc_hd__diode_2
XANTENNA_62 wbs_dat_i[10] wire9/VGND VSUBS _283_/VPB wire9/VPWR sky130_fd_sc_hd__diode_2
XANTENNA_51 wbs_dat_i[0] wire9/VGND VSUBS _243_/VPB wire9/VPWR sky130_fd_sc_hd__diode_2
X_392_ wire9/VGND VSUBS _393_/VPB wire9/VPWR _392_/HI la_data_out[61] sky130_fd_sc_hd__conb_1
X_461_ wire9/VGND VSUBS _476_/VPB wire9/VPWR _461_/HI user_irq[2] sky130_fd_sc_hd__conb_1
X_444_ wire9/VGND VSUBS _446_/VPB wire9/VPWR _444_/HI la_data_out[113] sky130_fd_sc_hd__conb_1
X_375_ wire9/VGND VSUBS _377_/VPB wire9/VPWR _375_/HI la_data_out[44] sky130_fd_sc_hd__conb_1
X_427_ wire9/VGND VSUBS _429_/VPB wire9/VPWR _427_/HI la_data_out[96] sky130_fd_sc_hd__conb_1
X_358_ _358_/CLK _358_/D wire9/VGND VSUBS _358_/VPB wire9/VPWR io_out[36] sky130_fd_sc_hd__dfxtp_1
XANTENNA_196 wbs_dat_i[8] wire9/VGND VSUBS _352_/VPB wire9/VPWR sky130_fd_sc_hd__diode_2
XANTENNA_163 wbs_dat_i[4] wire9/VGND VSUBS _348_/VPB wire9/VPWR sky130_fd_sc_hd__diode_2
XANTENNA_185 wbs_dat_i[6] wire9/VGND VSUBS _247_/VPB wire9/VPWR sky130_fd_sc_hd__diode_2
XANTENNA_152 wbs_dat_i[3] wire9/VGND VSUBS _247_/VPB wire9/VPWR sky130_fd_sc_hd__diode_2
XANTENNA_141 wbs_dat_i[2] wire9/VGND VSUBS _247_/VPB wire9/VPWR sky130_fd_sc_hd__diode_2
XANTENNA_130 wbs_dat_i[1] wire9/VGND VSUBS _197_/VPB wire9/VPWR sky130_fd_sc_hd__diode_2
XANTENNA_174 wbs_dat_i[5] wire9/VGND VSUBS _359_/VPB wire9/VPWR sky130_fd_sc_hd__diode_2
X_289_ _285_/Y _288_/Y _327_/B wire9/VGND VSUBS _292_/VPB wire9/VPWR _289_/Y sky130_fd_sc_hd__o21ai_0
X_212_ la_data_in[51] _212_/B wire9/VGND VSUBS _222_/VPB wire9/VPWR _212_/Y sky130_fd_sc_hd__nand2_1
XANTENNA_41 wbs_cyc_i wire9/VGND VSUBS _181_/VPB wire9/VPWR sky130_fd_sc_hd__diode_2
XANTENNA_85 wbs_dat_i[12] wire9/VGND VSUBS _342_/VPB wire9/VPWR sky130_fd_sc_hd__diode_2
XANTENNA_96 wbs_dat_i[13] wire9/VGND VSUBS _342_/VPB wire9/VPWR sky130_fd_sc_hd__diode_2
XANTENNA_74 wbs_dat_i[11] wire9/VGND VSUBS _292_/VPB wire9/VPWR sky130_fd_sc_hd__diode_2
XANTENNA_63 wbs_dat_i[10] wire9/VGND VSUBS _283_/VPB wire9/VPWR sky130_fd_sc_hd__diode_2
XANTENNA_30 wb_rst_i wire9/VGND VSUBS _485_/VPB wire9/VPWR sky130_fd_sc_hd__diode_2
XANTENNA_52 wbs_dat_i[0] wire9/VGND VSUBS _243_/VPB wire9/VPWR sky130_fd_sc_hd__diode_2
X_391_ wire9/VGND VSUBS _393_/VPB wire9/VPWR _391_/HI la_data_out[60] sky130_fd_sc_hd__conb_1
X_460_ wire9/VGND VSUBS _477_/VPB wire9/VPWR _460_/HI user_irq[1] sky130_fd_sc_hd__conb_1
X_443_ wire9/VGND VSUBS _446_/VPB wire9/VPWR _443_/HI la_data_out[112] sky130_fd_sc_hd__conb_1
X_374_ wire9/VGND VSUBS _377_/VPB wire9/VPWR _374_/HI la_data_out[43] sky130_fd_sc_hd__conb_1
XANTENNA_142 wbs_dat_i[2] wire9/VGND VSUBS _247_/VPB wire9/VPWR sky130_fd_sc_hd__diode_2
XANTENNA_131 wbs_dat_i[1] wire9/VGND VSUBS _243_/VPB wire9/VPWR sky130_fd_sc_hd__diode_2
XANTENNA_120 wbs_dat_i[15] wire9/VGND VSUBS _283_/VPB wire9/VPWR sky130_fd_sc_hd__diode_2
X_426_ wire9/VGND VSUBS _426_/VPB wire9/VPWR _426_/HI la_data_out[95] sky130_fd_sc_hd__conb_1
X_357_ _358_/CLK _357_/D wire9/VGND VSUBS _357_/VPB wire9/VPWR io_out[35] sky130_fd_sc_hd__dfxtp_1
X_288_ _323_/B _296_/B _288_/C wire9/VGND VSUBS _303_/VPB wire9/VPWR _288_/Y sky130_fd_sc_hd__nor3_1
XANTENNA_197 wbs_dat_i[8] wire9/VGND VSUBS _352_/VPB wire9/VPWR sky130_fd_sc_hd__diode_2
XANTENNA_164 wbs_dat_i[4] wire9/VGND VSUBS _348_/VPB wire9/VPWR sky130_fd_sc_hd__diode_2
XANTENNA_186 wbs_dat_i[6] wire9/VGND VSUBS _247_/VPB wire9/VPWR sky130_fd_sc_hd__diode_2
XANTENNA_153 wbs_dat_i[3] wire9/VGND VSUBS _247_/VPB wire9/VPWR sky130_fd_sc_hd__diode_2
XANTENNA_175 wbs_dat_i[5] wire9/VGND VSUBS wire2/VPB wire9/VPWR sky130_fd_sc_hd__diode_2
X_211_ io_oeb[7] _211_/B wire9/VGND VSUBS _211_/VPB wire9/VPWR _346_/D sky130_fd_sc_hd__nor2_1
X_409_ wire9/VGND VSUBS _409_/VPB wire9/VPWR _409_/HI la_data_out[78] sky130_fd_sc_hd__conb_1
XANTENNA_42 wbs_cyc_i wire9/VGND VSUBS _356_/VPB wire9/VPWR sky130_fd_sc_hd__diode_2
XANTENNA_20 wb_clk_i wire9/VGND VSUBS _320_/VPB wire9/VPWR sky130_fd_sc_hd__diode_2
XANTENNA_86 wbs_dat_i[12] wire9/VGND VSUBS _293_/VPB wire9/VPWR sky130_fd_sc_hd__diode_2
XANTENNA_97 wbs_dat_i[13] wire9/VGND VSUBS _342_/VPB wire9/VPWR sky130_fd_sc_hd__diode_2
XANTENNA_75 wbs_dat_i[11] wire9/VGND VSUBS _292_/VPB wire9/VPWR sky130_fd_sc_hd__diode_2
XANTENNA_64 wbs_dat_i[10] wire9/VGND VSUBS _283_/VPB wire9/VPWR sky130_fd_sc_hd__diode_2
XANTENNA_31 wb_rst_i wire9/VGND VSUBS _485_/VPB wire9/VPWR sky130_fd_sc_hd__diode_2
XANTENNA_53 wbs_dat_i[0] wire9/VGND VSUBS _243_/VPB wire9/VPWR sky130_fd_sc_hd__diode_2
Xclkbuf_0_mprj.counter.clk _168_/X wire9/VGND VSUBS _320_/VPB wire9/VPWR clkbuf_0_mprj.counter.clk/X
+ sky130_fd_sc_hd__clkbuf_16
X_390_ wire9/VGND VSUBS _390_/VPB wire9/VPWR _390_/HI la_data_out[59] sky130_fd_sc_hd__conb_1
X_442_ wire9/VGND VSUBS _442_/VPB wire9/VPWR _442_/HI la_data_out[111] sky130_fd_sc_hd__conb_1
X_373_ wire9/VGND VSUBS _377_/VPB wire9/VPWR _373_/HI la_data_out[42] sky130_fd_sc_hd__conb_1
X_425_ wire9/VGND VSUBS _426_/VPB wire9/VPWR _425_/HI la_data_out[94] sky130_fd_sc_hd__conb_1
X_356_ _356_/CLK _356_/D wire9/VGND VSUBS _356_/VPB wire9/VPWR io_out[34] sky130_fd_sc_hd__dfxtp_1
X_287_ io_out[32] _295_/D io_out[33] wire9/VGND VSUBS _303_/VPB wire9/VPWR _288_/C
+ sky130_fd_sc_hd__a21oi_1
XANTENNA_187 wbs_dat_i[8] wire9/VGND VSUBS _352_/VPB wire9/VPWR sky130_fd_sc_hd__diode_2
XANTENNA_154 wbs_dat_i[4] wire9/VGND VSUBS _350_/VPB wire9/VPWR sky130_fd_sc_hd__diode_2
XANTENNA_176 wbs_dat_i[6] wire9/VGND VSUBS _247_/VPB wire9/VPWR sky130_fd_sc_hd__diode_2
XANTENNA_143 wbs_dat_i[3] wire9/VGND VSUBS _247_/VPB wire9/VPWR sky130_fd_sc_hd__diode_2
XANTENNA_132 wbs_dat_i[2] wire9/VGND VSUBS _247_/VPB wire9/VPWR sky130_fd_sc_hd__diode_2
XANTENNA_198 wbs_dat_i[9] wire9/VGND VSUBS wire2/VPB wire9/VPWR sky130_fd_sc_hd__diode_2
XANTENNA_121 wbs_dat_i[1] wire9/VGND VSUBS _243_/VPB wire9/VPWR sky130_fd_sc_hd__diode_2
XANTENNA_165 wbs_dat_i[5] wire9/VGND VSUBS _335_/VPB wire9/VPWR sky130_fd_sc_hd__diode_2
XANTENNA_110 wbs_dat_i[15] wire9/VGND VSUBS _335_/VPB wire9/VPWR sky130_fd_sc_hd__diode_2
X_408_ wire9/VGND VSUBS _409_/VPB wire9/VPWR _408_/HI la_data_out[77] sky130_fd_sc_hd__conb_1
X_210_ _210_/A _210_/B wire9/VGND VSUBS _346_/VPB wire9/VPWR _211_/B sky130_fd_sc_hd__nor2_1
X_339_ _356_/CLK io_out[33] _167_/Y wire9/VGND VSUBS _339_/VPB wire9/VPWR wbs_dat_o[11]
+ sky130_fd_sc_hd__edfxtp_1
XANTENNA_43 wbs_cyc_i wire9/VGND VSUBS _356_/VPB wire9/VPWR sky130_fd_sc_hd__diode_2
XANTENNA_21 wb_clk_i wire9/VGND VSUBS _320_/VPB wire9/VPWR sky130_fd_sc_hd__diode_2
XANTENNA_65 wbs_dat_i[10] wire9/VGND VSUBS _283_/VPB wire9/VPWR sky130_fd_sc_hd__diode_2
XANTENNA_10 wire5/A wire9/VGND VSUBS wire5/VPB wire9/VPWR sky130_fd_sc_hd__diode_2
XANTENNA_32 wb_rst_i wire9/VGND VSUBS _485_/VPB wire9/VPWR sky130_fd_sc_hd__diode_2
XANTENNA_54 wbs_dat_i[0] wire9/VGND VSUBS _243_/VPB wire9/VPWR sky130_fd_sc_hd__diode_2
XANTENNA_87 wbs_dat_i[12] wire9/VGND VSUBS _342_/VPB wire9/VPWR sky130_fd_sc_hd__diode_2
XANTENNA_98 wbs_dat_i[13] wire9/VGND VSUBS _342_/VPB wire9/VPWR sky130_fd_sc_hd__diode_2
XANTENNA_76 wbs_dat_i[11] wire9/VGND VSUBS _292_/VPB wire9/VPWR sky130_fd_sc_hd__diode_2
Xspare_mux2_0 spare_mux2_0/A0 spare_mux2_0/A1 spare_mux2_0/S wire9/VGND VSUBS spare_mux2_0/VPB
+ wire9/VPWR spare_mux2_0/X sky130_fd_sc_hd__mux2_2
Xclkbuf_2_3__f_mprj.counter.clk clkbuf_0_mprj.counter.clk/X wire9/VGND VSUBS clkload2/VPB
+ wire9/VPWR _356_/CLK sky130_fd_sc_hd__clkbuf_16
X_441_ wire9/VGND VSUBS _442_/VPB wire9/VPWR _441_/HI la_data_out[110] sky130_fd_sc_hd__conb_1
X_372_ wire9/VGND VSUBS _377_/VPB wire9/VPWR _372_/HI la_data_out[41] sky130_fd_sc_hd__conb_1
X_424_ wire9/VGND VSUBS _426_/VPB wire9/VPWR _424_/HI la_data_out[93] sky130_fd_sc_hd__conb_1
X_286_ io_out[32] io_out[33] _295_/D wire9/VGND VSUBS _303_/VPB wire9/VPWR _296_/B
+ sky130_fd_sc_hd__and3_1
XANTENNA_100 wbs_dat_i[14] wire9/VGND VSUBS _358_/VPB wire9/VPWR sky130_fd_sc_hd__diode_2
X_355_ _358_/CLK _355_/D wire9/VGND VSUBS _355_/VPB wire9/VPWR io_out[33] sky130_fd_sc_hd__dfxtp_1
XANTENNA_188 wbs_dat_i[8] wire9/VGND VSUBS _352_/VPB wire9/VPWR sky130_fd_sc_hd__diode_2
XANTENNA_155 wbs_dat_i[4] wire9/VGND VSUBS _348_/VPB wire9/VPWR sky130_fd_sc_hd__diode_2
XANTENNA_177 wbs_dat_i[6] wire9/VGND VSUBS _247_/VPB wire9/VPWR sky130_fd_sc_hd__diode_2
XANTENNA_144 wbs_dat_i[3] wire9/VGND VSUBS _247_/VPB wire9/VPWR sky130_fd_sc_hd__diode_2
XANTENNA_133 wbs_dat_i[2] wire9/VGND VSUBS _247_/VPB wire9/VPWR sky130_fd_sc_hd__diode_2
XANTENNA_199 wbs_dat_i[9] wire9/VGND VSUBS wire2/VPB wire9/VPWR sky130_fd_sc_hd__diode_2
XANTENNA_122 wbs_dat_i[1] wire9/VGND VSUBS _197_/VPB wire9/VPWR sky130_fd_sc_hd__diode_2
XANTENNA_166 wbs_dat_i[5] wire9/VGND VSUBS _335_/VPB wire9/VPWR sky130_fd_sc_hd__diode_2
XANTENNA_111 wbs_dat_i[15] wire9/VGND VSUBS _335_/VPB wire9/VPWR sky130_fd_sc_hd__diode_2
X_338_ _356_/CLK io_out[32] _167_/Y wire9/VGND VSUBS _338_/VPB wire9/VPWR wbs_dat_o[10]
+ sky130_fd_sc_hd__edfxtp_1
X_407_ wire9/VGND VSUBS _409_/VPB wire9/VPWR _407_/HI la_data_out[76] sky130_fd_sc_hd__conb_1
X_269_ io_out[7] io_out[30] io_out[31] _269_/D wire9/VGND VSUBS _271_/VPB wire9/VPWR
+ _295_/D sky130_fd_sc_hd__and4_1
XANTENNA_22 wb_clk_i wire9/VGND VSUBS _320_/VPB wire9/VPWR sky130_fd_sc_hd__diode_2
XANTENNA_99 wbs_dat_i[14] wire9/VGND VSUBS _358_/VPB wire9/VPWR sky130_fd_sc_hd__diode_2
XANTENNA_77 wbs_dat_i[12] wire9/VGND VSUBS _342_/VPB wire9/VPWR sky130_fd_sc_hd__diode_2
XANTENNA_88 wbs_dat_i[13] wire9/VGND VSUBS _342_/VPB wire9/VPWR sky130_fd_sc_hd__diode_2
XANTENNA_66 wbs_dat_i[11] wire9/VGND VSUBS _292_/VPB wire9/VPWR sky130_fd_sc_hd__diode_2
XANTENNA_55 wbs_dat_i[10] wire9/VGND VSUBS _283_/VPB wire9/VPWR sky130_fd_sc_hd__diode_2
XANTENNA_11 _333_/Q wire9/VGND VSUBS wire14/VPB wire9/VPWR sky130_fd_sc_hd__diode_2
XANTENNA_33 wb_rst_i wire9/VGND VSUBS _485_/VPB wire9/VPWR sky130_fd_sc_hd__diode_2
XANTENNA_44 wbs_dat_i[0] wire9/VGND VSUBS _243_/VPB wire9/VPWR sky130_fd_sc_hd__diode_2
Xspare_nand2_0 spare_nand2_0/A spare_nand2_0/B wire9/VGND VSUBS spare_nand2_0/VPB
+ wire9/VPWR spare_nand2_0/Y sky130_fd_sc_hd__nand2_2
X_440_ wire9/VGND VSUBS _442_/VPB wire9/VPWR _440_/HI la_data_out[109] sky130_fd_sc_hd__conb_1
X_371_ wire9/VGND VSUBS _377_/VPB wire9/VPWR _371_/HI la_data_out[40] sky130_fd_sc_hd__conb_1
X_423_ wire9/VGND VSUBS _426_/VPB wire9/VPWR _423_/HI la_data_out[92] sky130_fd_sc_hd__conb_1
XANTENNA_101 wbs_dat_i[14] wire9/VGND VSUBS _358_/VPB wire9/VPWR sky130_fd_sc_hd__diode_2
X_285_ la_oenb[59] _318_/B la_data_in[59] wire9/VGND VSUBS _405_/VPB wire9/VPWR _285_/Y
+ sky130_fd_sc_hd__nor3b_1
XANTENNA_189 wbs_dat_i[8] wire9/VGND VSUBS _352_/VPB wire9/VPWR sky130_fd_sc_hd__diode_2
X_354_ _358_/CLK _354_/D wire9/VGND VSUBS _393_/VPB wire9/VPWR io_out[32] sky130_fd_sc_hd__dfxtp_1
XANTENNA_156 wbs_dat_i[4] wire9/VGND VSUBS _348_/VPB wire9/VPWR sky130_fd_sc_hd__diode_2
XANTENNA_178 wbs_dat_i[6] wire9/VGND VSUBS _247_/VPB wire9/VPWR sky130_fd_sc_hd__diode_2
XANTENNA_145 wbs_dat_i[3] wire9/VGND VSUBS _247_/VPB wire9/VPWR sky130_fd_sc_hd__diode_2
XANTENNA_134 wbs_dat_i[2] wire9/VGND VSUBS _247_/VPB wire9/VPWR sky130_fd_sc_hd__diode_2
XANTENNA_123 wbs_dat_i[1] wire9/VGND VSUBS _243_/VPB wire9/VPWR sky130_fd_sc_hd__diode_2
XANTENNA_112 wbs_dat_i[15] wire9/VGND VSUBS _335_/VPB wire9/VPWR sky130_fd_sc_hd__diode_2
XANTENNA_167 wbs_dat_i[5] wire9/VGND VSUBS _359_/VPB wire9/VPWR sky130_fd_sc_hd__diode_2
X_406_ wire9/VGND VSUBS _409_/VPB wire9/VPWR _406_/HI la_data_out[75] sky130_fd_sc_hd__conb_1
X_337_ _351_/CLK io_out[31] _167_/Y wire9/VGND VSUBS _337_/VPB wire9/VPWR wire6/A
+ sky130_fd_sc_hd__edfxtp_1
X_199_ _255_/A _195_/Y _197_/Y _198_/Y wire9/VGND VSUBS _203_/VPB wire9/VPWR _200_/B
+ sky130_fd_sc_hd__a31oi_1
X_268_ la_oenb[57] _318_/B la_data_in[57] wire9/VGND VSUBS _390_/VPB wire9/VPWR _268_/Y
+ sky130_fd_sc_hd__nor3b_1
XANTENNA_12 wb_clk_i wire9/VGND VSUBS _320_/VPB wire9/VPWR sky130_fd_sc_hd__diode_2
XANTENNA_78 wbs_dat_i[12] wire9/VGND VSUBS _342_/VPB wire9/VPWR sky130_fd_sc_hd__diode_2
XANTENNA_89 wbs_dat_i[13] wire9/VGND VSUBS _342_/VPB wire9/VPWR sky130_fd_sc_hd__diode_2
XANTENNA_67 wbs_dat_i[11] wire9/VGND VSUBS _292_/VPB wire9/VPWR sky130_fd_sc_hd__diode_2
XANTENNA_34 wbs_cyc_i wire9/VGND VSUBS _393_/VPB wire9/VPWR sky130_fd_sc_hd__diode_2
XANTENNA_56 wbs_dat_i[10] wire9/VGND VSUBS _283_/VPB wire9/VPWR sky130_fd_sc_hd__diode_2
XANTENNA_23 wb_rst_i wire9/VGND VSUBS _485_/VPB wire9/VPWR sky130_fd_sc_hd__diode_2
XANTENNA_45 wbs_dat_i[0] wire9/VGND VSUBS _243_/VPB wire9/VPWR sky130_fd_sc_hd__diode_2
X_370_ wire9/VGND VSUBS _370_/VPB wire9/VPWR _370_/HI la_data_out[39] sky130_fd_sc_hd__conb_1
X_422_ wire9/VGND VSUBS _426_/VPB wire9/VPWR _422_/HI la_data_out[91] sky130_fd_sc_hd__conb_1
XANTENNA_102 wbs_dat_i[14] wire9/VGND VSUBS _358_/VPB wire9/VPWR sky130_fd_sc_hd__diode_2
X_284_ _280_/Y _283_/Y io_oeb[7] wire9/VGND VSUBS _284_/VPB wire9/VPWR _354_/D sky130_fd_sc_hd__a21oi_1
XANTENNA_157 wbs_dat_i[4] wire9/VGND VSUBS _348_/VPB wire9/VPWR sky130_fd_sc_hd__diode_2
XANTENNA_179 wbs_dat_i[6] wire9/VGND VSUBS _247_/VPB wire9/VPWR sky130_fd_sc_hd__diode_2
XANTENNA_146 wbs_dat_i[3] wire9/VGND VSUBS _247_/VPB wire9/VPWR sky130_fd_sc_hd__diode_2
XANTENNA_135 wbs_dat_i[2] wire9/VGND VSUBS _247_/VPB wire9/VPWR sky130_fd_sc_hd__diode_2
XANTENNA_124 wbs_dat_i[1] wire9/VGND VSUBS _197_/VPB wire9/VPWR sky130_fd_sc_hd__diode_2
XANTENNA_113 wbs_dat_i[15] wire9/VGND VSUBS _335_/VPB wire9/VPWR sky130_fd_sc_hd__diode_2
X_353_ _358_/CLK _353_/D wire9/VGND VSUBS _359_/VPB wire9/VPWR io_out[31] sky130_fd_sc_hd__dfxtp_1
XANTENNA_168 wbs_dat_i[5] wire9/VGND VSUBS _359_/VPB wire9/VPWR sky130_fd_sc_hd__diode_2
X_405_ wire9/VGND VSUBS _405_/VPB wire9/VPWR _405_/HI la_data_out[74] sky130_fd_sc_hd__conb_1
X_267_ _261_/Y _266_/Y io_oeb[7] wire9/VGND VSUBS _342_/VPB wire9/VPWR _352_/D sky130_fd_sc_hd__a21oi_1
X_198_ wbs_dat_i[1] _255_/A _165_/X wire9/VGND VSUBS _243_/VPB wire9/VPWR _198_/Y
+ sky130_fd_sc_hd__o21ai_0
X_336_ _351_/CLK io_out[30] _167_/Y wire9/VGND VSUBS _336_/VPB wire9/VPWR wire7/A
+ sky130_fd_sc_hd__edfxtp_1
XANTENNA_13 wb_clk_i wire9/VGND VSUBS _320_/VPB wire9/VPWR sky130_fd_sc_hd__diode_2
XANTENNA_79 wbs_dat_i[12] wire9/VGND VSUBS _342_/VPB wire9/VPWR sky130_fd_sc_hd__diode_2
XANTENNA_68 wbs_dat_i[11] wire9/VGND VSUBS _292_/VPB wire9/VPWR sky130_fd_sc_hd__diode_2
XANTENNA_35 wbs_cyc_i wire9/VGND VSUBS _393_/VPB wire9/VPWR sky130_fd_sc_hd__diode_2
XANTENNA_57 wbs_dat_i[10] wire9/VGND VSUBS _283_/VPB wire9/VPWR sky130_fd_sc_hd__diode_2
XANTENNA_24 wb_rst_i wire9/VGND VSUBS _485_/VPB wire9/VPWR sky130_fd_sc_hd__diode_2
XANTENNA_46 wbs_dat_i[0] wire9/VGND VSUBS _243_/VPB wire9/VPWR sky130_fd_sc_hd__diode_2
X_319_ io_out[35] io_out[36] io_out[37] _319_/D wire9/VGND VSUBS _320_/VPB wire9/VPWR
+ _321_/B sky130_fd_sc_hd__and4_1
X_421_ wire9/VGND VSUBS _421_/VPB wire9/VPWR _421_/HI la_data_out[90] sky130_fd_sc_hd__conb_1
XANTENNA_103 wbs_dat_i[14] wire9/VGND VSUBS _358_/VPB wire9/VPWR sky130_fd_sc_hd__diode_2
XANTENNA_158 wbs_dat_i[4] wire9/VGND VSUBS _348_/VPB wire9/VPWR sky130_fd_sc_hd__diode_2
XANTENNA_147 wbs_dat_i[3] wire9/VGND VSUBS _247_/VPB wire9/VPWR sky130_fd_sc_hd__diode_2
XANTENNA_136 wbs_dat_i[2] wire9/VGND VSUBS _247_/VPB wire9/VPWR sky130_fd_sc_hd__diode_2
XANTENNA_125 wbs_dat_i[1] wire9/VGND VSUBS _243_/VPB wire9/VPWR sky130_fd_sc_hd__diode_2
XANTENNA_114 wbs_dat_i[15] wire9/VGND VSUBS _335_/VPB wire9/VPWR sky130_fd_sc_hd__diode_2
X_352_ _358_/CLK _352_/D wire9/VGND VSUBS _352_/VPB wire9/VPWR io_out[30] sky130_fd_sc_hd__dfxtp_1
XANTENNA_169 wbs_dat_i[5] wire9/VGND VSUBS wire2/VPB wire9/VPWR sky130_fd_sc_hd__diode_2
X_283_ wbs_dat_i[10] _324_/A _279_/Y _282_/Y _165_/X wire9/VGND VSUBS _283_/VPB wire9/VPWR
+ _283_/Y sky130_fd_sc_hd__o221ai_1
X_404_ wire9/VGND VSUBS _405_/VPB wire9/VPWR _404_/HI la_data_out[73] sky130_fd_sc_hd__conb_1
X_266_ wbs_dat_i[8] _324_/A _265_/Y _260_/Y _165_/X wire9/VGND VSUBS _352_/VPB wire9/VPWR
+ _266_/Y sky130_fd_sc_hd__o221ai_1
X_197_ io_out[1] _323_/B wire9/VGND VSUBS _197_/VPB wire9/VPWR _197_/Y sky130_fd_sc_hd__nand2_1
X_335_ _351_/CLK io_out[7] _167_/Y wire9/VGND VSUBS _335_/VPB wire9/VPWR wire8/A sky130_fd_sc_hd__edfxtp_1
XANTENNA_36 wbs_cyc_i wire9/VGND VSUBS _356_/VPB wire9/VPWR sky130_fd_sc_hd__diode_2
XANTENNA_14 wb_clk_i wire9/VGND VSUBS _320_/VPB wire9/VPWR sky130_fd_sc_hd__diode_2
XANTENNA_69 wbs_dat_i[11] wire9/VGND VSUBS _292_/VPB wire9/VPWR sky130_fd_sc_hd__diode_2
XANTENNA_58 wbs_dat_i[10] wire9/VGND VSUBS _283_/VPB wire9/VPWR sky130_fd_sc_hd__diode_2
XANTENNA_25 wb_rst_i wire9/VGND VSUBS _485_/VPB wire9/VPWR sky130_fd_sc_hd__diode_2
XANTENNA_47 wbs_dat_i[0] wire9/VGND VSUBS _243_/VPB wire9/VPWR sky130_fd_sc_hd__diode_2
X_249_ la_oenb[55] _318_/B la_data_in[55] wire9/VGND VSUBS _393_/VPB wire9/VPWR _249_/Y
+ sky130_fd_sc_hd__nor3b_1
X_318_ la_oenb[63] _318_/B la_data_in[63] wire9/VGND VSUBS _318_/VPB wire9/VPWR _318_/Y
+ sky130_fd_sc_hd__nor3b_1
X_420_ wire9/VGND VSUBS _421_/VPB wire9/VPWR _420_/HI la_data_out[89] sky130_fd_sc_hd__conb_1
XANTENNA_104 wbs_dat_i[14] wire9/VGND VSUBS _358_/VPB wire9/VPWR sky130_fd_sc_hd__diode_2
X_282_ _324_/A _282_/B wire9/VGND VSUBS _282_/VPB wire9/VPWR _282_/Y sky130_fd_sc_hd__nand2_1
X_351_ _351_/CLK _351_/D wire9/VGND VSUBS _351_/VPB wire9/VPWR io_out[7] sky130_fd_sc_hd__dfxtp_1
XANTENNA_159 wbs_dat_i[4] wire9/VGND VSUBS _350_/VPB wire9/VPWR sky130_fd_sc_hd__diode_2
XANTENNA_148 wbs_dat_i[3] wire9/VGND VSUBS _247_/VPB wire9/VPWR sky130_fd_sc_hd__diode_2
XANTENNA_137 wbs_dat_i[2] wire9/VGND VSUBS _247_/VPB wire9/VPWR sky130_fd_sc_hd__diode_2
XANTENNA_126 wbs_dat_i[1] wire9/VGND VSUBS _197_/VPB wire9/VPWR sky130_fd_sc_hd__diode_2
XANTENNA_115 wbs_dat_i[15] wire9/VGND VSUBS _335_/VPB wire9/VPWR sky130_fd_sc_hd__diode_2
X_403_ wire9/VGND VSUBS _405_/VPB wire9/VPWR _403_/HI la_data_out[72] sky130_fd_sc_hd__conb_1
X_334_ _351_/CLK io_out[6] _167_/Y wire9/VGND VSUBS _350_/VPB wire9/VPWR wire9/A sky130_fd_sc_hd__edfxtp_1
XANTENNA_37 wbs_cyc_i wire9/VGND VSUBS _356_/VPB wire9/VPWR sky130_fd_sc_hd__diode_2
XANTENNA_15 wb_clk_i wire9/VGND VSUBS _320_/VPB wire9/VPWR sky130_fd_sc_hd__diode_2
X_265_ _324_/A _265_/B wire9/VGND VSUBS _342_/VPB wire9/VPWR _265_/Y sky130_fd_sc_hd__nand2_1
XANTENNA_59 wbs_dat_i[10] wire9/VGND VSUBS _283_/VPB wire9/VPWR sky130_fd_sc_hd__diode_2
XANTENNA_26 wb_rst_i wire9/VGND VSUBS _485_/VPB wire9/VPWR sky130_fd_sc_hd__diode_2
X_196_ _193_/Y _195_/Y _165_/X wire9/VGND VSUBS _196_/VPB wire9/VPWR _200_/A sky130_fd_sc_hd__a21oi_1
XANTENNA_48 wbs_dat_i[0] wire9/VGND VSUBS _243_/VPB wire9/VPWR sky130_fd_sc_hd__diode_2
X_179_ la_oenb[49] la_oenb[52] la_oenb[54] la_oenb[55] _318_/B wire9/VGND VSUBS _412_/VPB
+ wire9/VPWR _184_/B sky130_fd_sc_hd__a41o_1
X_317_ _313_/Y _316_/Y io_oeb[7] wire9/VGND VSUBS _342_/VPB wire9/VPWR _358_/D sky130_fd_sc_hd__a21oi_1
X_248_ io_oeb[7] _248_/B wire9/VGND VSUBS _350_/VPB wire9/VPWR _350_/D sky130_fd_sc_hd__nor2_1
XANTENNA_105 wbs_dat_i[14] wire9/VGND VSUBS _358_/VPB wire9/VPWR sky130_fd_sc_hd__diode_2
X_281_ io_out[32] _323_/B wire9/VGND VSUBS _284_/VPB wire9/VPWR _282_/B sky130_fd_sc_hd__nand2_1
X_350_ _351_/CLK _350_/D wire9/VGND VSUBS _350_/VPB wire9/VPWR io_out[6] sky130_fd_sc_hd__dfxtp_1
XANTENNA_149 wbs_dat_i[3] wire9/VGND VSUBS _247_/VPB wire9/VPWR sky130_fd_sc_hd__diode_2
XANTENNA_138 wbs_dat_i[2] wire9/VGND VSUBS _247_/VPB wire9/VPWR sky130_fd_sc_hd__diode_2
XANTENNA_127 wbs_dat_i[1] wire9/VGND VSUBS _243_/VPB wire9/VPWR sky130_fd_sc_hd__diode_2
XANTENNA_116 wbs_dat_i[15] wire9/VGND VSUBS _335_/VPB wire9/VPWR sky130_fd_sc_hd__diode_2
X_479_ wire9/VGND VSUBS _481_/VPB wire9/VPWR _479_/HI la_data_out[17] sky130_fd_sc_hd__conb_1
X_402_ wire9/VGND VSUBS _405_/VPB wire9/VPWR _402_/HI la_data_out[71] sky130_fd_sc_hd__conb_1
X_264_ io_out[30] _323_/B wire9/VGND VSUBS _352_/VPB wire9/VPWR _265_/B sky130_fd_sc_hd__nand2_1
X_333_ _351_/CLK io_out[5] _167_/Y wire9/VGND VSUBS _343_/VPB wire9/VPWR _333_/Q sky130_fd_sc_hd__edfxtp_1
X_195_ io_out[0] io_out[1] _194_/Y wire9/VGND VSUBS _197_/VPB wire9/VPWR _195_/Y sky130_fd_sc_hd__o21ai_0
XANTENNA_38 wbs_cyc_i wire9/VGND VSUBS _356_/VPB wire9/VPWR sky130_fd_sc_hd__diode_2
XANTENNA_16 wb_clk_i wire9/VGND VSUBS _320_/VPB wire9/VPWR sky130_fd_sc_hd__diode_2
XANTENNA_27 wb_rst_i wire9/VGND VSUBS _485_/VPB wire9/VPWR sky130_fd_sc_hd__diode_2
XANTENNA_49 wbs_dat_i[0] wire9/VGND VSUBS _243_/VPB wire9/VPWR sky130_fd_sc_hd__diode_2
X_316_ wbs_dat_i[14] _324_/A _312_/Y _315_/Y _165_/X wire9/VGND VSUBS _358_/VPB wire9/VPWR
+ _316_/Y sky130_fd_sc_hd__o221ai_1
X_247_ _165_/X _244_/Y _245_/Y _246_/Y wire9/VGND VSUBS _247_/VPB wire9/VPWR _248_/B
+ sky130_fd_sc_hd__o22a_1
X_178_ la_oenb[50] la_oenb[51] la_oenb[57] la_oenb[59] _318_/B wire9/VGND VSUBS _409_/VPB
+ wire9/VPWR _184_/A sky130_fd_sc_hd__a41o_1
Xspare_aoi_0 spare_aoi_0/A1 spare_aoi_0/A2 spare_aoi_0/B1 wire9/VGND VSUBS spare_aoi_0/VPB
+ wire9/VPWR spare_aoi_0/Y sky130_fd_sc_hd__a21oi_2
XANTENNA_106 wbs_dat_i[14] wire9/VGND VSUBS _358_/VPB wire9/VPWR sky130_fd_sc_hd__diode_2
X_280_ _277_/Y _279_/Y _327_/B wire9/VGND VSUBS _283_/VPB wire9/VPWR _280_/Y sky130_fd_sc_hd__o21ai_0
XANTENNA_139 wbs_dat_i[2] wire9/VGND VSUBS _247_/VPB wire9/VPWR sky130_fd_sc_hd__diode_2
XANTENNA_128 wbs_dat_i[1] wire9/VGND VSUBS _197_/VPB wire9/VPWR sky130_fd_sc_hd__diode_2
XANTENNA_117 wbs_dat_i[15] wire9/VGND VSUBS _335_/VPB wire9/VPWR sky130_fd_sc_hd__diode_2
X_478_ wire9/VGND VSUBS _481_/VPB wire9/VPWR _478_/HI la_data_out[16] sky130_fd_sc_hd__conb_1
X_263_ wbs_sel_i[1] wbs_we_i wire9/VGND VSUBS _342_/VPB wire9/VPWR _324_/A sky130_fd_sc_hd__nand2_1
X_401_ wire9/VGND VSUBS _405_/VPB wire9/VPWR _401_/HI la_data_out[70] sky130_fd_sc_hd__conb_1
X_332_ _351_/CLK io_out[4] _167_/Y wire9/VGND VSUBS _332_/VPB wire9/VPWR _332_/Q sky130_fd_sc_hd__edfxtp_1
X_194_ io_out[0] io_out[1] _323_/B wire9/VGND VSUBS _194_/VPB wire9/VPWR _194_/Y sky130_fd_sc_hd__a21oi_1
XANTENNA_39 wbs_cyc_i wire9/VGND VSUBS _356_/VPB wire9/VPWR sky130_fd_sc_hd__diode_2
XANTENNA_17 wb_clk_i wire9/VGND VSUBS _320_/VPB wire9/VPWR sky130_fd_sc_hd__diode_2
XANTENNA_28 wb_rst_i wire9/VGND VSUBS _485_/VPB wire9/VPWR sky130_fd_sc_hd__diode_2
X_315_ _324_/A _315_/B wire9/VGND VSUBS _342_/VPB wire9/VPWR _315_/Y sky130_fd_sc_hd__nand2_1
X_246_ wbs_dat_i[6] _255_/A _165_/X wire9/VGND VSUBS _247_/VPB wire9/VPWR _246_/Y
+ sky130_fd_sc_hd__o21ai_0
X_177_ la_oenb[51] _318_/B wire9/VGND VSUBS _384_/VPB wire9/VPWR _212_/B sky130_fd_sc_hd__nor2_1
X_229_ _255_/A _225_/Y _227_/Y _228_/Y wire9/VGND VSUBS _348_/VPB wire9/VPWR _230_/B
+ sky130_fd_sc_hd__a31oi_1
XANTENNA_107 wbs_dat_i[14] wire9/VGND VSUBS _358_/VPB wire9/VPWR sky130_fd_sc_hd__diode_2
XANTENNA_129 wbs_dat_i[1] wire9/VGND VSUBS _243_/VPB wire9/VPWR sky130_fd_sc_hd__diode_2
XANTENNA_118 wbs_dat_i[15] wire9/VGND VSUBS _335_/VPB wire9/VPWR sky130_fd_sc_hd__diode_2
X_477_ wire9/VGND VSUBS _477_/VPB wire9/VPWR _477_/HI wbs_dat_o[31] sky130_fd_sc_hd__conb_1
X_262_ wbs_sel_i[1] wbs_we_i wire9/VGND VSUBS _341_/VPB wire9/VPWR _262_/X sky130_fd_sc_hd__and2_0
X_400_ wire9/VGND VSUBS _405_/VPB wire9/VPWR _400_/HI la_data_out[69] sky130_fd_sc_hd__conb_1
X_331_ _360_/CLK io_out[3] _167_/Y wire9/VGND VSUBS _331_/VPB wire9/VPWR _331_/Q sky130_fd_sc_hd__edfxtp_1
X_193_ la_data_in[49] _193_/B wire9/VGND VSUBS _381_/VPB wire9/VPWR _193_/Y sky130_fd_sc_hd__nand2_1
Xwire2 wire2/A wire9/VGND VSUBS wire2/VPB wire9/VPWR wbs_ack_o sky130_fd_sc_hd__buf_12
XANTENNA_18 wb_clk_i wire9/VGND VSUBS _320_/VPB wire9/VPWR sky130_fd_sc_hd__diode_2
XANTENNA_29 wb_rst_i wire9/VGND VSUBS _485_/VPB wire9/VPWR sky130_fd_sc_hd__diode_2
X_314_ io_out[36] _323_/B wire9/VGND VSUBS _342_/VPB wire9/VPWR _315_/B sky130_fd_sc_hd__nand2_1
X_245_ wbs_we_i wbs_sel_i[0] _323_/B io_out[6] _243_/Y wire9/VGND VSUBS _247_/VPB
+ wire9/VPWR _245_/Y sky130_fd_sc_hd__a221oi_1
X_176_ la_oenb[53] _318_/B wire9/VGND VSUBS _176_/VPB wire9/VPWR _232_/B sky130_fd_sc_hd__nor2_1
X_228_ wbs_dat_i[4] _255_/A _165_/X wire9/VGND VSUBS _350_/VPB wire9/VPWR _228_/Y
+ sky130_fd_sc_hd__o21ai_0
XANTENNA_108 wbs_dat_i[14] wire9/VGND VSUBS _300_/VPB wire9/VPWR sky130_fd_sc_hd__diode_2
XANTENNA_119 wbs_dat_i[15] wire9/VGND VSUBS _243_/VPB wire9/VPWR sky130_fd_sc_hd__diode_2
X_476_ wire9/VGND VSUBS _476_/VPB wire9/VPWR _476_/HI wbs_dat_o[30] sky130_fd_sc_hd__conb_1
X_261_ _258_/Y _260_/Y _327_/B wire9/VGND VSUBS _261_/VPB wire9/VPWR _261_/Y sky130_fd_sc_hd__o21ai_0
Xwire3 wire3/A wire9/VGND VSUBS wire3/VPB wire9/VPWR wbs_dat_o[15] sky130_fd_sc_hd__buf_12
X_330_ _351_/CLK io_out[2] _167_/Y wire9/VGND VSUBS _330_/VPB wire9/VPWR _330_/Q sky130_fd_sc_hd__edfxtp_1
X_192_ io_oeb[7] _192_/B wire9/VGND VSUBS _192_/VPB wire9/VPWR _344_/D sky130_fd_sc_hd__nor2_1
XANTENNA_19 wb_clk_i wire9/VGND VSUBS _320_/VPB wire9/VPWR sky130_fd_sc_hd__diode_2
X_459_ wire9/VGND VSUBS _477_/VPB wire9/VPWR _459_/HI user_irq[0] sky130_fd_sc_hd__conb_1
X_313_ _310_/Y _312_/Y _327_/B wire9/VGND VSUBS _358_/VPB wire9/VPWR _313_/Y sky130_fd_sc_hd__o21ai_0
X_244_ la_data_in[54] _174_/Y _243_/Y wire9/VGND VSUBS _247_/VPB wire9/VPWR _244_/Y
+ sky130_fd_sc_hd__a21oi_1
X_175_ la_oenb[50] _318_/B wire9/VGND VSUBS _384_/VPB wire9/VPWR _202_/B sky130_fd_sc_hd__nor2_1
XANTENNA_280 wbs_ack_o wire9/VGND VSUBS _283_/VPB wire9/VPWR sky130_fd_sc_hd__diode_2
X_227_ io_out[4] _323_/B wire9/VGND VSUBS _247_/VPB wire9/VPWR _227_/Y sky130_fd_sc_hd__nand2_1
XANTENNA_109 wbs_dat_i[14] wire9/VGND VSUBS _300_/VPB wire9/VPWR sky130_fd_sc_hd__diode_2
X_475_ wire9/VGND VSUBS _475_/VPB wire9/VPWR _475_/HI wbs_dat_o[29] sky130_fd_sc_hd__conb_1
X_260_ io_out[30] _252_/B _259_/Y wire9/VGND VSUBS _352_/VPB wire9/VPWR _260_/Y sky130_fd_sc_hd__a21oi_1
Xwire4 wire4/A wire9/VGND VSUBS wire4/VPB wire9/VPWR wbs_dat_o[14] sky130_fd_sc_hd__buf_12
X_389_ wire9/VGND VSUBS _390_/VPB wire9/VPWR _389_/HI la_data_out[58] sky130_fd_sc_hd__conb_1
X_458_ wire9/VGND VSUBS _458_/VPB wire9/VPWR _458_/HI la_data_out[127] sky130_fd_sc_hd__conb_1
X_191_ _327_/B _185_/Y _190_/Y wire9/VGND VSUBS _192_/VPB wire9/VPWR _192_/B sky130_fd_sc_hd__a21oi_1
X_312_ io_out[35] io_out[36] _319_/D _311_/Y _323_/B wire9/VGND VSUBS _320_/VPB wire9/VPWR
+ _312_/Y sky130_fd_sc_hd__a311oi_1
X_243_ _323_/B _243_/B _269_/D wire9/VGND VSUBS _243_/VPB wire9/VPWR _243_/Y sky130_fd_sc_hd__nor3_1
X_174_ la_oenb[54] _318_/B wire9/VGND VSUBS _185_/VPB wire9/VPWR _174_/Y sky130_fd_sc_hd__nor2_1
XANTENNA_270 wbs_we_i wire9/VGND VSUBS _242_/VPB wire9/VPWR sky130_fd_sc_hd__diode_2
XANTENNA_281 wbs_ack_o wire9/VGND VSUBS _283_/VPB wire9/VPWR sky130_fd_sc_hd__diode_2
X_226_ _222_/Y _225_/Y _165_/X wire9/VGND VSUBS _348_/VPB wire9/VPWR _230_/A sky130_fd_sc_hd__a21oi_1
X_209_ _255_/A _205_/X _207_/Y _208_/Y wire9/VGND VSUBS _216_/VPB wire9/VPWR _210_/B
+ sky130_fd_sc_hd__a31oi_1
X_491_ wire9/VGND VSUBS _491_/VPB wire9/VPWR _491_/HI la_data_out[29] sky130_fd_sc_hd__conb_1
X_474_ wire9/VGND VSUBS _474_/VPB wire9/VPWR _474_/HI wbs_dat_o[28] sky130_fd_sc_hd__conb_1
Xwire5 wire5/A wire9/VGND VSUBS wire5/VPB wire9/VPWR wbs_dat_o[13] sky130_fd_sc_hd__buf_12
X_190_ _190_/A _190_/B wire9/VGND VSUBS _243_/VPB wire9/VPWR _190_/Y sky130_fd_sc_hd__nor2_1
X_457_ wire9/VGND VSUBS _458_/VPB wire9/VPWR _457_/HI la_data_out[126] sky130_fd_sc_hd__conb_1
X_388_ wire9/VGND VSUBS _390_/VPB wire9/VPWR _388_/HI la_data_out[57] sky130_fd_sc_hd__conb_1
X_173_ wbs_stb_i wbs_cyc_i la_oenb[61] wire9/VGND VSUBS _356_/VPB wire9/VPWR _183_/A
+ sky130_fd_sc_hd__a21oi_1
X_311_ io_out[35] _319_/D io_out[36] wire9/VGND VSUBS _320_/VPB wire9/VPWR _311_/Y
+ sky130_fd_sc_hd__a21oi_1
X_242_ io_out[6] io_out[5] io_out[4] _242_/D wire9/VGND VSUBS _242_/VPB wire9/VPWR
+ _269_/D sky130_fd_sc_hd__and4_1
XANTENNA_260 wbs_stb_i wire9/VGND VSUBS _181_/VPB wire9/VPWR sky130_fd_sc_hd__diode_2
XANTENNA_271 wbs_we_i wire9/VGND VSUBS _358_/VPB wire9/VPWR sky130_fd_sc_hd__diode_2
XANTENNA_282 wbs_ack_o wire9/VGND VSUBS _283_/VPB wire9/VPWR sky130_fd_sc_hd__diode_2
Xwire10 _333_/Q wire9/VGND VSUBS wire14/VPB wire9/VPWR wbs_dat_o[5] sky130_fd_sc_hd__buf_12
X_225_ io_out[4] _242_/D _224_/Y wire9/VGND VSUBS _247_/VPB wire9/VPWR _225_/Y sky130_fd_sc_hd__o21ai_0
X_208_ wbs_dat_i[2] _255_/A _165_/X wire9/VGND VSUBS _247_/VPB wire9/VPWR _208_/Y
+ sky130_fd_sc_hd__o21ai_0
X_490_ wire9/VGND VSUBS _491_/VPB wire9/VPWR _490_/HI la_data_out[28] sky130_fd_sc_hd__conb_1
X_473_ wire9/VGND VSUBS _473_/VPB wire9/VPWR _473_/HI wbs_dat_o[27] sky130_fd_sc_hd__conb_1
Xwire6 wire6/A wire9/VGND VSUBS wire9/VPB wire9/VPWR wbs_dat_o[9] sky130_fd_sc_hd__buf_12
X_456_ wire9/VGND VSUBS _458_/VPB wire9/VPWR _456_/HI la_data_out[125] sky130_fd_sc_hd__conb_1
X_387_ wire9/VGND VSUBS _387_/VPB wire9/VPWR _387_/HI la_data_out[56] sky130_fd_sc_hd__conb_1
X_310_ la_oenb[62] _318_/B la_data_in[62] wire9/VGND VSUBS _310_/VPB wire9/VPWR _310_/Y
+ sky130_fd_sc_hd__nor3b_1
XANTENNA_261 wbs_stb_i wire9/VGND VSUBS _356_/VPB wire9/VPWR sky130_fd_sc_hd__diode_2
XANTENNA_272 wbs_we_i wire9/VGND VSUBS _342_/VPB wire9/VPWR sky130_fd_sc_hd__diode_2
XANTENNA_250 wbs_sel_i[1] wire9/VGND VSUBS _342_/VPB wire9/VPWR sky130_fd_sc_hd__diode_2
X_439_ wire9/VGND VSUBS _442_/VPB wire9/VPWR _439_/HI la_data_out[108] sky130_fd_sc_hd__conb_1
X_241_ io_out[5] _224_/B io_out[6] wire9/VGND VSUBS _242_/VPB wire9/VPWR _243_/B sky130_fd_sc_hd__a21oi_1
X_172_ la_oenb[52] _318_/B wire9/VGND VSUBS _176_/VPB wire9/VPWR _222_/B sky130_fd_sc_hd__nor2_1
XANTENNA_283 wbs_ack_o wire9/VGND VSUBS _283_/VPB wire9/VPWR sky130_fd_sc_hd__diode_2
Xwire11 _332_/Q wire9/VGND VSUBS wire11/VPB wire9/VPWR wbs_dat_o[4] sky130_fd_sc_hd__buf_12
X_224_ _323_/B _224_/B wire9/VGND VSUBS _247_/VPB wire9/VPWR _224_/Y sky130_fd_sc_hd__nor2_1
Xspare_tielo_drv wire9/VGND VSUBS spare_tielo_drv/VPB wire9/VPWR spare_tielo_drv/HI
+ spare_tielo_drv/LO sky130_fd_sc_hd__conb_1
X_207_ io_out[2] _323_/B wire9/VGND VSUBS _247_/VPB wire9/VPWR _207_/Y sky130_fd_sc_hd__nand2_1
X_472_ wire9/VGND VSUBS _472_/VPB wire9/VPWR _472_/HI wbs_dat_o[26] sky130_fd_sc_hd__conb_1
Xwire7 wire7/A wire9/VGND VSUBS wire7/VPB wire9/VPWR wbs_dat_o[8] sky130_fd_sc_hd__buf_12
X_455_ wire9/VGND VSUBS _458_/VPB wire9/VPWR _455_/HI la_data_out[124] sky130_fd_sc_hd__conb_1
X_386_ wire9/VGND VSUBS _387_/VPB wire9/VPWR _386_/HI la_data_out[55] sky130_fd_sc_hd__conb_1
XANTENNA_240 wbs_sel_i[1] wire9/VGND VSUBS _341_/VPB wire9/VPWR sky130_fd_sc_hd__diode_2
XANTENNA_251 wbs_sel_i[1] wire9/VGND VSUBS _342_/VPB wire9/VPWR sky130_fd_sc_hd__diode_2
X_240_ io_oeb[7] _240_/B wire9/VGND VSUBS _349_/VPB wire9/VPWR _349_/D sky130_fd_sc_hd__nor2_1
X_171_ la_oenb[49] _318_/B wire9/VGND VSUBS _176_/VPB wire9/VPWR _193_/B sky130_fd_sc_hd__nor2_1
XANTENNA_262 wbs_stb_i wire9/VGND VSUBS _356_/VPB wire9/VPWR sky130_fd_sc_hd__diode_2
XANTENNA_273 wbs_we_i wire9/VGND VSUBS _358_/VPB wire9/VPWR sky130_fd_sc_hd__diode_2
Xwire12 _331_/Q wire9/VGND VSUBS wire9/VPB wire9/VPWR wbs_dat_o[3] sky130_fd_sc_hd__buf_12
X_438_ wire9/VGND VSUBS _438_/VPB wire9/VPWR _438_/HI la_data_out[107] sky130_fd_sc_hd__conb_1
X_369_ wire9/VGND VSUBS _370_/VPB wire9/VPWR _369_/HI la_data_out[38] sky130_fd_sc_hd__conb_1
XANTENNA_284 wbs_ack_o wire9/VGND VSUBS _283_/VPB wire9/VPWR sky130_fd_sc_hd__diode_2
X_223_ io_out[4] _242_/D wire9/VGND VSUBS _242_/VPB wire9/VPWR _224_/B sky130_fd_sc_hd__and2_0
X_206_ _202_/Y _205_/X _165_/X wire9/VGND VSUBS _206_/VPB wire9/VPWR _210_/A sky130_fd_sc_hd__a21oi_1
X_471_ wire9/VGND VSUBS _473_/VPB wire9/VPWR _471_/HI wbs_dat_o[25] sky130_fd_sc_hd__conb_1
Xwire8 wire8/A wire9/VGND VSUBS wire8/VPB wire9/VPWR wbs_dat_o[7] sky130_fd_sc_hd__buf_12
X_454_ wire9/VGND VSUBS _454_/VPB wire9/VPWR _454_/HI la_data_out[123] sky130_fd_sc_hd__conb_1
X_385_ wire9/VGND VSUBS _387_/VPB wire9/VPWR _385_/HI la_data_out[54] sky130_fd_sc_hd__conb_1
X_170_ la_data_in[48] _170_/B wire9/VGND VSUBS _344_/VPB wire9/VPWR _170_/Y sky130_fd_sc_hd__nand2_1
X_299_ io_out[34] _323_/B wire9/VGND VSUBS _300_/VPB wire9/VPWR _300_/B sky130_fd_sc_hd__nand2_1
XANTENNA_274 wbs_we_i wire9/VGND VSUBS _358_/VPB wire9/VPWR sky130_fd_sc_hd__diode_2
XANTENNA_241 wbs_sel_i[1] wire9/VGND VSUBS _341_/VPB wire9/VPWR sky130_fd_sc_hd__diode_2
XANTENNA_252 wbs_sel_i[1] wire9/VGND VSUBS _342_/VPB wire9/VPWR sky130_fd_sc_hd__diode_2
Xwire13 _330_/Q wire9/VGND VSUBS wire13/VPB wire9/VPWR wbs_dat_o[2] sky130_fd_sc_hd__buf_12
X_437_ wire9/VGND VSUBS _438_/VPB wire9/VPWR _437_/HI la_data_out[106] sky130_fd_sc_hd__conb_1
X_368_ wire9/VGND VSUBS _370_/VPB wire9/VPWR _368_/HI la_data_out[37] sky130_fd_sc_hd__conb_1
XANTENNA_263 wbs_we_i wire9/VGND VSUBS _247_/VPB wire9/VPWR sky130_fd_sc_hd__diode_2
XANTENNA_230 wbs_sel_i[0] wire9/VGND VSUBS _242_/VPB wire9/VPWR sky130_fd_sc_hd__diode_2
XANTENNA_285 wbs_ack_o wire9/VGND VSUBS _283_/VPB wire9/VPWR sky130_fd_sc_hd__diode_2
X_222_ la_data_in[52] _222_/B wire9/VGND VSUBS _222_/VPB wire9/VPWR _222_/Y sky130_fd_sc_hd__nand2_1
X_205_ _323_/B _205_/B _205_/C wire9/VGND VSUBS _247_/VPB wire9/VPWR _205_/X sky130_fd_sc_hd__or3_1
X_470_ wire9/VGND VSUBS _470_/VPB wire9/VPWR _470_/HI wbs_dat_o[24] sky130_fd_sc_hd__conb_1
Xwire9 wire9/A wire9/VGND VSUBS wire9/VPB wire9/VPWR wbs_dat_o[6] sky130_fd_sc_hd__buf_12
X_453_ wire9/VGND VSUBS _454_/VPB wire9/VPWR _453_/HI la_data_out[122] sky130_fd_sc_hd__conb_1
X_384_ wire9/VGND VSUBS _384_/VPB wire9/VPWR _384_/HI la_data_out[53] sky130_fd_sc_hd__conb_1
X_298_ _294_/Y _297_/Y _327_/B wire9/VGND VSUBS _300_/VPB wire9/VPWR _298_/Y sky130_fd_sc_hd__o21ai_0
XANTENNA_231 wbs_sel_i[1] wire9/VGND VSUBS _341_/VPB wire9/VPWR sky130_fd_sc_hd__diode_2
XANTENNA_275 wbs_we_i wire9/VGND VSUBS _342_/VPB wire9/VPWR sky130_fd_sc_hd__diode_2
XANTENNA_242 wbs_sel_i[1] wire9/VGND VSUBS _342_/VPB wire9/VPWR sky130_fd_sc_hd__diode_2
XANTENNA_253 wbs_stb_i wire9/VGND VSUBS _393_/VPB wire9/VPWR sky130_fd_sc_hd__diode_2
X_436_ wire9/VGND VSUBS _438_/VPB wire9/VPWR _436_/HI la_data_out[105] sky130_fd_sc_hd__conb_1
X_367_ wire9/VGND VSUBS _367_/VPB wire9/VPWR _367_/HI la_data_out[36] sky130_fd_sc_hd__conb_1
XANTENNA_264 wbs_we_i wire9/VGND VSUBS _247_/VPB wire9/VPWR sky130_fd_sc_hd__diode_2
XANTENNA_220 wbs_sel_i[0] wire9/VGND VSUBS _247_/VPB wire9/VPWR sky130_fd_sc_hd__diode_2
XANTENNA_286 wbs_ack_o wire9/VGND VSUBS _283_/VPB wire9/VPWR sky130_fd_sc_hd__diode_2
Xwire14 _329_/Q wire9/VGND VSUBS wire14/VPB wire9/VPWR wbs_dat_o[1] sky130_fd_sc_hd__buf_12
X_221_ io_oeb[7] _221_/B wire9/VGND VSUBS _347_/VPB wire9/VPWR _347_/D sky130_fd_sc_hd__nor2_1
X_419_ wire9/VGND VSUBS _421_/VPB wire9/VPWR _419_/HI la_data_out[88] sky130_fd_sc_hd__conb_1
X_204_ io_out[2] io_out[0] io_out[1] wire9/VGND VSUBS _247_/VPB wire9/VPWR _205_/C
+ sky130_fd_sc_hd__and3_1
XANTENNA_1 la_data_in[55] wire9/VGND VSUBS _390_/VPB wire9/VPWR sky130_fd_sc_hd__diode_2
X_452_ wire9/VGND VSUBS _454_/VPB wire9/VPWR _452_/HI la_data_out[121] sky130_fd_sc_hd__conb_1
X_383_ wire9/VGND VSUBS _384_/VPB wire9/VPWR _383_/HI la_data_out[52] sky130_fd_sc_hd__conb_1
X_297_ _323_/B _319_/D _297_/C wire9/VGND VSUBS _300_/VPB wire9/VPWR _297_/Y sky130_fd_sc_hd__nor3_1
XANTENNA_232 wbs_sel_i[1] wire9/VGND VSUBS _341_/VPB wire9/VPWR sky130_fd_sc_hd__diode_2
XANTENNA_276 wbs_we_i wire9/VGND VSUBS _342_/VPB wire9/VPWR sky130_fd_sc_hd__diode_2
XANTENNA_243 wbs_sel_i[1] wire9/VGND VSUBS _342_/VPB wire9/VPWR sky130_fd_sc_hd__diode_2
XANTENNA_254 wbs_stb_i wire9/VGND VSUBS _393_/VPB wire9/VPWR sky130_fd_sc_hd__diode_2
X_435_ wire9/VGND VSUBS _438_/VPB wire9/VPWR _435_/HI la_data_out[104] sky130_fd_sc_hd__conb_1
X_366_ wire9/VGND VSUBS _367_/VPB wire9/VPWR _366_/HI la_data_out[35] sky130_fd_sc_hd__conb_1
XANTENNA_265 wbs_we_i wire9/VGND VSUBS _247_/VPB wire9/VPWR sky130_fd_sc_hd__diode_2
XANTENNA_210 wbs_sel_i[0] wire9/VGND VSUBS _247_/VPB wire9/VPWR sky130_fd_sc_hd__diode_2
XANTENNA_221 wbs_sel_i[0] wire9/VGND VSUBS _247_/VPB wire9/VPWR sky130_fd_sc_hd__diode_2
XANTENNA_287 wbs_ack_o wire9/VGND VSUBS _283_/VPB wire9/VPWR sky130_fd_sc_hd__diode_2
X_220_ _220_/A _220_/B wire9/VGND VSUBS _220_/VPB wire9/VPWR _221_/B sky130_fd_sc_hd__nor2_1
X_418_ wire9/VGND VSUBS _421_/VPB wire9/VPWR _418_/HI la_data_out[87] sky130_fd_sc_hd__conb_1
X_349_ _360_/CLK _349_/D wire9/VGND VSUBS _349_/VPB wire9/VPWR io_out[5] sky130_fd_sc_hd__dfxtp_1
X_203_ io_out[0] io_out[1] io_out[2] wire9/VGND VSUBS _203_/VPB wire9/VPWR _205_/B
+ sky130_fd_sc_hd__a21oi_1
XANTENNA_2 la_data_in[56] wire9/VGND VSUBS _258_/VPB wire9/VPWR sky130_fd_sc_hd__diode_2
X_451_ wire9/VGND VSUBS _454_/VPB wire9/VPWR _451_/HI la_data_out[120] sky130_fd_sc_hd__conb_1
X_382_ wire9/VGND VSUBS _384_/VPB wire9/VPWR _382_/HI la_data_out[51] sky130_fd_sc_hd__conb_1
XANTENNA_255 wbs_stb_i wire9/VGND VSUBS _356_/VPB wire9/VPWR sky130_fd_sc_hd__diode_2
X_296_ io_out[34] _296_/B wire9/VGND VSUBS _320_/VPB wire9/VPWR _297_/C sky130_fd_sc_hd__nor2_1
XANTENNA_233 wbs_sel_i[1] wire9/VGND VSUBS _341_/VPB wire9/VPWR sky130_fd_sc_hd__diode_2
XANTENNA_277 wbs_we_i wire9/VGND VSUBS _342_/VPB wire9/VPWR sky130_fd_sc_hd__diode_2
XANTENNA_244 wbs_sel_i[1] wire9/VGND VSUBS _342_/VPB wire9/VPWR sky130_fd_sc_hd__diode_2
X_434_ wire9/VGND VSUBS _434_/VPB wire9/VPWR _434_/HI la_data_out[103] sky130_fd_sc_hd__conb_1
X_365_ wire9/VGND VSUBS _367_/VPB wire9/VPWR _365_/HI la_data_out[34] sky130_fd_sc_hd__conb_1
XANTENNA_211 wbs_sel_i[0] wire9/VGND VSUBS _247_/VPB wire9/VPWR sky130_fd_sc_hd__diode_2
XANTENNA_222 wbs_sel_i[0] wire9/VGND VSUBS _247_/VPB wire9/VPWR sky130_fd_sc_hd__diode_2
XANTENNA_266 wbs_we_i wire9/VGND VSUBS _242_/VPB wire9/VPWR sky130_fd_sc_hd__diode_2
XANTENNA_200 wbs_dat_i[9] wire9/VGND VSUBS wire2/VPB wire9/VPWR sky130_fd_sc_hd__diode_2
Xclkbuf_2_0__f_mprj.counter.clk clkbuf_0_mprj.counter.clk/X wire9/VGND VSUBS _256_/VPB
+ wire9/VPWR _351_/CLK sky130_fd_sc_hd__clkbuf_16
XANTENNA_288 wbs_ack_o wire9/VGND VSUBS _283_/VPB wire9/VPWR sky130_fd_sc_hd__diode_2
X_417_ wire9/VGND VSUBS _417_/VPB wire9/VPWR _417_/HI la_data_out[86] sky130_fd_sc_hd__conb_1
X_279_ io_out[32] _295_/D _278_/Y wire9/VGND VSUBS _292_/VPB wire9/VPWR _279_/Y sky130_fd_sc_hd__a21oi_1
X_348_ _360_/CLK _348_/D wire9/VGND VSUBS _348_/VPB wire9/VPWR io_out[4] sky130_fd_sc_hd__dfxtp_1
X_202_ la_data_in[50] _202_/B wire9/VGND VSUBS _370_/VPB wire9/VPWR _202_/Y sky130_fd_sc_hd__nand2_1
XANTENNA_3 la_data_in[57] wire9/VGND VSUBS _387_/VPB wire9/VPWR sky130_fd_sc_hd__diode_2
X_450_ wire9/VGND VSUBS _450_/VPB wire9/VPWR _450_/HI la_data_out[119] sky130_fd_sc_hd__conb_1
Xspare_nor2_0 spare_nor2_0/A spare_nor2_0/B wire9/VGND VSUBS spare_nor2_0/VPB wire9/VPWR
+ spare_nor2_0/Y sky130_fd_sc_hd__nor2_2
X_381_ wire9/VGND VSUBS _381_/VPB wire9/VPWR _381_/HI la_data_out[50] sky130_fd_sc_hd__conb_1
XANTENNA_256 wbs_stb_i wire9/VGND VSUBS _356_/VPB wire9/VPWR sky130_fd_sc_hd__diode_2
XANTENNA_234 wbs_sel_i[1] wire9/VGND VSUBS _341_/VPB wire9/VPWR sky130_fd_sc_hd__diode_2
XANTENNA_245 wbs_sel_i[1] wire9/VGND VSUBS _342_/VPB wire9/VPWR sky130_fd_sc_hd__diode_2
X_433_ wire9/VGND VSUBS _434_/VPB wire9/VPWR _433_/HI la_data_out[102] sky130_fd_sc_hd__conb_1
XANTENNA_267 wbs_we_i wire9/VGND VSUBS _247_/VPB wire9/VPWR sky130_fd_sc_hd__diode_2
XANTENNA_212 wbs_sel_i[0] wire9/VGND VSUBS _247_/VPB wire9/VPWR sky130_fd_sc_hd__diode_2
XANTENNA_223 wbs_sel_i[0] wire9/VGND VSUBS _247_/VPB wire9/VPWR sky130_fd_sc_hd__diode_2
XANTENNA_201 wbs_dat_i[9] wire9/VGND VSUBS wire2/VPB wire9/VPWR sky130_fd_sc_hd__diode_2
X_295_ io_out[32] io_out[33] io_out[34] _295_/D wire9/VGND VSUBS _320_/VPB wire9/VPWR
+ _319_/D sky130_fd_sc_hd__and4_1
XANTENNA_278 wbs_we_i wire9/VGND VSUBS _342_/VPB wire9/VPWR sky130_fd_sc_hd__diode_2
X_364_ wire9/VGND VSUBS _364_/VPB wire9/VPWR _364_/HI la_data_out[33] sky130_fd_sc_hd__conb_1
XANTENNA_289 wbs_ack_o wire9/VGND VSUBS _283_/VPB wire9/VPWR sky130_fd_sc_hd__diode_2
X_416_ wire9/VGND VSUBS _417_/VPB wire9/VPWR _416_/HI la_data_out[85] sky130_fd_sc_hd__conb_1
X_278_ io_out[32] _295_/D _323_/B wire9/VGND VSUBS _284_/VPB wire9/VPWR _278_/Y sky130_fd_sc_hd__o21bai_1
X_347_ _360_/CLK _347_/D wire9/VGND VSUBS _347_/VPB wire9/VPWR io_out[3] sky130_fd_sc_hd__dfxtp_1
X_201_ io_oeb[7] _201_/B wire9/VGND VSUBS _346_/VPB wire9/VPWR _345_/D sky130_fd_sc_hd__nor2_1
XANTENNA_4 la_data_in[58] wire9/VGND VSUBS _393_/VPB wire9/VPWR sky130_fd_sc_hd__diode_2
X_380_ wire9/VGND VSUBS _381_/VPB wire9/VPWR _380_/HI la_data_out[49] sky130_fd_sc_hd__conb_1
RWALIAS0 io_oeb[7] io_oeb[0] 0
RWALIAS1 io_oeb[7] io_oeb[1] 0
RWALIAS2 io_oeb[7] io_oeb[2] 0
RWALIAS3 io_oeb[7] io_oeb[30] 0
RWALIAS4 io_oeb[7] io_oeb[31] 0
RWALIAS5 io_oeb[7] io_oeb[32] 0
RWALIAS6 io_oeb[7] io_oeb[33] 0
RWALIAS7 io_oeb[7] io_oeb[34] 0
RWALIAS8 io_oeb[7] io_oeb[35] 0
RWALIAS9 io_oeb[7] io_oeb[36] 0
RWALIAS10 io_oeb[7] io_oeb[37] 0
RWALIAS11 io_oeb[7] io_oeb[3] 0
RWALIAS12 io_oeb[7] io_oeb[4] 0
RWALIAS13 io_oeb[7] io_oeb[5] 0
RWALIAS14 io_oeb[7] io_oeb[6] 0
RWALIAS15 io_out[9] io_oeb[10] 0
RWALIAS16 io_out[9] io_oeb[11] 0
RWALIAS17 io_out[9] io_oeb[12] 0
RWALIAS18 io_out[9] io_oeb[13] 0
RWALIAS19 io_out[9] io_oeb[14] 0
RWALIAS20 io_out[9] io_oeb[15] 0
RWALIAS21 io_out[9] io_oeb[16] 0
RWALIAS22 io_out[9] io_oeb[17] 0
RWALIAS23 io_out[9] io_oeb[18] 0
RWALIAS24 io_out[9] io_oeb[19] 0
RWALIAS25 io_out[9] io_oeb[20] 0
RWALIAS26 io_out[9] io_oeb[21] 0
RWALIAS27 io_out[9] io_oeb[22] 0
RWALIAS28 io_out[9] io_oeb[23] 0
RWALIAS29 io_out[9] io_oeb[24] 0
RWALIAS30 io_out[9] io_oeb[25] 0
RWALIAS31 io_out[9] io_oeb[26] 0
RWALIAS32 io_out[9] io_oeb[27] 0
RWALIAS33 io_out[9] io_oeb[28] 0
RWALIAS34 io_out[9] io_oeb[29] 0
RWALIAS35 io_out[9] io_oeb[8] 0
RWALIAS36 io_out[9] io_oeb[9] 0
RWALIAS37 io_out[9] io_out[10] 0
RWALIAS38 io_out[9] io_out[11] 0
RWALIAS39 io_out[9] io_out[12] 0
RWALIAS40 io_out[9] io_out[13] 0
RWALIAS41 io_out[9] io_out[14] 0
RWALIAS42 io_out[9] io_out[15] 0
RWALIAS43 io_out[9] io_out[16] 0
RWALIAS44 io_out[9] io_out[17] 0
RWALIAS45 io_out[9] io_out[18] 0
RWALIAS46 io_out[9] io_out[19] 0
RWALIAS47 io_out[9] io_out[20] 0
RWALIAS48 io_out[9] io_out[21] 0
RWALIAS49 io_out[9] io_out[22] 0
RWALIAS50 io_out[9] io_out[23] 0
RWALIAS51 io_out[9] io_out[24] 0
RWALIAS52 io_out[9] io_out[25] 0
RWALIAS53 io_out[9] io_out[26] 0
RWALIAS54 io_out[9] io_out[27] 0
RWALIAS55 io_out[9] io_out[28] 0
RWALIAS56 io_out[9] io_out[29] 0
RWALIAS57 io_out[9] io_out[8] 0
RWALIAS58 io_out[0] la_data_out[0] 0
RWALIAS59 io_out[1] la_data_out[1] 0
RWALIAS60 io_out[2] la_data_out[2] 0
RWALIAS61 io_out[30] la_data_out[8] 0
RWALIAS62 io_out[31] la_data_out[9] 0
RWALIAS63 io_out[32] la_data_out[10] 0
RWALIAS64 io_out[33] la_data_out[11] 0
RWALIAS65 io_out[34] la_data_out[12] 0
RWALIAS66 io_out[35] la_data_out[13] 0
RWALIAS67 io_out[36] la_data_out[14] 0
RWALIAS68 io_out[37] la_data_out[15] 0
RWALIAS69 io_out[3] la_data_out[3] 0
RWALIAS70 io_out[4] la_data_out[4] 0
RWALIAS71 io_out[5] la_data_out[5] 0
RWALIAS72 io_out[6] la_data_out[6] 0
RWALIAS73 io_out[7] la_data_out[7] 0
.ends
