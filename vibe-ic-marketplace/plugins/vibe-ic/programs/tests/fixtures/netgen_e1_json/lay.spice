.subckt top a b
M1 a b vss vss nfet w=1u l=0.15u
.ends
